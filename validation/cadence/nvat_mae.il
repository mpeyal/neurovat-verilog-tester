; Maestro setups that mirror the batch decks exactly (options, tran settings,
; stimulus, saved signals).  Lisp-syntax SKILL, loaded through skillbridge.

(procedure (nvatPwl name)
  (strcat "\"" (getShellEnvVar "HOME") "/nvat_spectre_run/pwl/" name ".pwl\""))

(procedure (nvatMaeTest sess tb test pwl stop maxstep simopts outputs extraTran @optional defs)
  (maeCreateTest test ?lib "NVAT_VAL" ?cell tb ?view "schematic" ?simulator "spectre" ?session sess)
  ; no PDK model include; optional Spectre definitions file (internal-node saves)
  (maeSetEnvOption test ?options (list (list "modelFiles" nil)) ?session sess)
  (when defs (maeSetEnvOption test ?options (list (list "definitionFiles" (list defs))) ?session sess))
  (maeSetAnalysis test "tran" ?enable t
    ?options (append (list (list "stop" stop) (list "maxstep" maxstep)
                           (list "errpreset" "conservative"))
                     extraTran)
    ?session sess)
  (maeSetSimOption test ?options simopts ?session sess)
  (foreach o outputs
    (maeAddOutput (car o) test ?outputType (caddr o) ?signalName (cadr o) ?plot t ?save t ?session sess))
  t)

(procedure (nvatMaeEcfet)
  (let (sess opts outs defs)
    (setq defs (strcat (getShellEnvVar "HOME") "/nvat_spectre_run/save_ecfet.scs"))
    (setq sess (maeOpenSetup "NVAT_VAL" "tb_ecfet_v3" "maestro" ?mode "w"))
    (setq opts (list (list "reltol" "1e-6") (list "vabstol" "1e-12") (list "iabstol" "1e-18")
                     (list "gmin" "1e-15") (list "temp" "27")))
    (setq outs (list (list "Rmem" "/n_rmem" "net") (list "n_igsc" "/n_igsc" "net")
                     (list "I_read" "/V0/PLUS" "terminal") (list "I_gate" "/I0/IGsc" "terminal")))
    (maeSetVar "pwlfile" (nvatPwl "v3_single_pulse") ?session sess)
    (nvatMaeTest sess "tb_ecfet_v3" "single_pulse"  "v3_single_pulse"  "2"     "1m" opts outs (list (list "ic" "node")) defs)
    (nvatMaeTest sess "tb_ecfet_v3" "gap_sweep"     "v3_gap_sweep"     "8.885" "2m" opts outs (list (list "ic" "node")) defs)
    (nvatMaeTest sess "tb_ecfet_v3" "ltp_ltd_train" "v3_ltp_ltd_train" "3.01"  "1m" opts outs (list (list "ic" "node")) defs)
    (maeSaveSetup ?session sess)
    sess))

(procedure (nvatMaeRram)
  (let (sess opts outs)
    (setq sess (maeOpenSetup "NVAT_VAL" "tb_rram" "maestro" ?mode "w"))
    (setq opts (list (list "reltol" "1e-5") (list "vabstol" "1e-9") (list "iabstol" "1e-15")
                     (list "gmin" "1e-15")))
    (setq outs (list (list "V_TE" "/n_te" "net") (list "I_TE" "/I0/TE" "terminal") (list "I_src" "/V0/PLUS" "terminal")))
    (maeSetVar "pwlfile" (nvatPwl "rram_pulse_reset_ref") ?session sess)
    (maeSetVar "tstep" "1e-10" ?session sess)
    (nvatMaeTest sess "tb_rram" "pulse_reset_ref" "rram_pulse_reset_ref" "2.0501e-07" "1e-10" opts outs nil)
    (nvatMaeTest sess "tb_rram" "s1_pm1p3"        "rram_s1_pm1p3"        "4.07e-07"   "1e-10" opts outs nil)
    (nvatMaeTest sess "tb_rram" "s1_pm1p4"        "rram_s1_pm1p4"        "4.07e-07"   "1e-10" opts outs nil)
    (maeSaveSetup ?session sess)
    sess))

; Dump selected signals of the currently opened OCEAN results ("tran") to a CSV.
(procedure (nvatDump psfdir sigs outfile)
  (let (port waves xv n row)
    (openResults psfdir)
    (selectResult "tran")
    (setq waves (mapcar (lambda (s) (getData s)) sigs))
    (setq xv (drGetWaveformXVec (car waves)))
    (setq n (drVectorLength xv))
    (setq port (outfile outfile))
    (fprintf port "t_s")
    (foreach s sigs (fprintf port ",%s" s))
    (fprintf port "\n")
    (for i 0 (difference n 1)
      (fprintf port "%.15g" (drGetElem xv i))
      (foreach w waves
        (fprintf port ",%.15g" (drGetElem (drGetWaveformYVec w) i)))
      (fprintf port "\n"))
    (close port)
    n))

(procedure (nvatLabelNet lib cell oldName newName)
  (let (cv net w bb pt)
    (setq cv (dbOpenCellViewByType lib cell "schematic" nil "a"))
    (setq net (dbFindNetByName cv oldName))
    (when net
      (setq w (car (setof f (getq net figs) (equal (getq f objType) "line"))))
      (when w
        (setq bb (getq w bBox))
        (setq pt (list (plus (xCoord (car bb)) 0.0625) (plus (yCoord (car bb)) 0.03125)))
        (schCreateWireLabel cv w pt newName "lowerLeft" "R0" "stick" 0.0625 nil)))
    (schCheck cv) (dbSave cv) (dbClose cv)
    (if net t nil)))

(procedure (nvatSnapSchematic lib cell path)
  (let (w)
    (setq w (geOpen ?lib lib ?cell cell ?view "schematic" ?mode "r"))
    (hiResizeWindow w (list (list 20 20) (list 1000 700)))
    (schZoomFit 1.0 0.85 w)
    (hiWindowSaveImage ?target w ?path path ?format "png" ?delay 1)
    w))

(procedure (nvatSnapWave psfdir sigs path)
  (let (w waves)
    (openResults psfdir)
    (selectResult "tran")
    (setq waves (mapcar (lambda (s) (getData s)) sigs))
    (setq w (awvCreatePlotWindow))
    (awvPlotWaveform w waves ?expr sigs)
    (when (greaterp (length sigs) 1) (awvSetDisplayMode w "strip"))
    (hiResizeWindow w (list (list 20 20) (list 1000 700)))
    (hiWindowSaveImage ?target w ?path path ?format "png" ?delay 2)
    w))
