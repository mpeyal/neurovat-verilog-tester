; NeuroVAT validation testbench builders (Lisp-syntax SKILL; loaded by skillbridge)

(procedure (nvatSym cell box pins title)
  (let (cv net fig lb nm pt tip hs cx cy)
    (setq cv (dbOpenCellViewByType "NVAT_VAL" cell "symbol" "schematicSymbol" "w"))
    (dbCreateRect cv (list "device" "drawing") box)
    (foreach pp pins
      (setq nm (nth 0 pp))
      (setq pt (nth 1 pp))
      (setq tip (nth 2 pp))
      (setq hs 0.03125)
      (dbCreateLine cv (list "device" "drawing") (list pt tip))
      (setq net (dbCreateNet cv nm))
      (dbCreateTerm net nm (or (nth 5 pp) "inputOutput"))
      (setq fig (dbCreateRect cv (list "pin" "drawing")
                  (list (list (difference (xCoord pt) hs) (difference (yCoord pt) hs))
                        (list (plus (xCoord pt) hs) (plus (yCoord pt) hs)))))
      (dbCreatePin net fig nm)
      (dbCreateLabel cv (list "pin" "drawing") (nth 3 pp) nm (nth 4 pp) "R0" "stick" 0.0625))
    (setq cx (quotient (plus (xCoord (car box)) (xCoord (cadr box))) 2.0))
    (setq cy (quotient (plus (yCoord (car box)) (yCoord (cadr box))) 2.0))
    (dbCreateLabel cv (list "device" "label") (list cx cy) title "centerCenter" "R0" "stick" 0.09375)
    (setq lb (dbCreateLabel cv (list "annotate" "drawing7")
               (list (plus (xCoord (cadr box)) 0.0625) (yCoord (cadr box)))
               "cdsName()" "upperLeft" "R0" "stick" 0.0625))
    (putprop lb "ILLabel" 'labelType)
    (dbCreateRect cv (list "instance" "drawing")
      (list (list (difference (xCoord (car box)) 0.25) (difference (yCoord (car box)) 0.25))
            (list (plus (xCoord (cadr box)) 0.25) (plus (yCoord (cadr box)) 0.25))))
    (dbSave cv)
    (dbClose cv)
    "OK"))

(procedure (nvatMakeSymbols)
  (nvatSym "ecfet_v3" (list (list -0.5 -0.375) (list 0.5 0.375))
    (list (list "In"   (list -0.75 0.0)  (list -0.5 0.0)   (list -0.45 0.05) "lowerLeft")
          (list "Out"  (list 0.75 0.0)   (list 0.5 0.0)    (list 0.45 0.05)  "lowerRight")
          (list "IGsc" (list 0.0 0.625)  (list 0.0 0.375)  (list 0.05 0.3)   "upperLeft" "input")
          (list "Rmem" (list 0.0 -0.625) (list 0.0 -0.375) (list 0.05 -0.3)  "lowerLeft" "output"))
    "ECFET v3")
  (nvatSym "rram_v_1_0_0" (list (list -0.25 -0.375) (list 0.25 0.375))
    (list (list "TE" (list 0.0 0.625)  (list 0.0 0.375)  (list 0.05 0.3)  "upperLeft")
          (list "BE" (list 0.0 -0.625) (list 0.0 -0.375) (list 0.05 -0.3) "lowerLeft"))
    "RRAM"))

; ---------------------------------------------------------------- schematic
(procedure (nvatTermPt inst termName)
  (let (pt bb c)
    (foreach tm (getq (getq inst master) terminals)
      (when (equal (getq tm name) termName)
        (setq bb (getq (getq (car (getq tm pins)) fig) bBox))))
    (setq c (list (quotient (plus (xCoord (car bb)) (xCoord (cadr bb))) 2.0)
                  (quotient (plus (yCoord (car bb)) (yCoord (cadr bb))) 2.0)))
    (dbTransformPoint c (getq inst transform))))

(procedure (nvatWire cv pts label)
  ; orthogonal wire through pts; optional net label at the first segment midpoint
  (let (w p1 p2)
    (setq w (car (schCreateWire cv "draw" "full" pts 0.0625 0.0625 0.0)))
    (when (and w label)
      (setq p1 (car pts)) (setq p2 (cadr pts))
      (schCreateWireLabel cv w
        (list (plus (quotient (plus (xCoord p1) (xCoord p2)) 2.0) 0.03125)
              (plus (quotient (plus (yCoord p1) (yCoord p2)) 2.0) 0.03125))
        label "lowerLeft" "R0" "stick" 0.0625 nil))
    w))

(procedure (nvatInst cv lib cell name xy orient params)
  (let (m inst)
    (setq m (dbOpenCellViewByType lib cell "symbol" nil "r"))
    (setq inst (dbCreateParamInst cv m name xy orient 1 params))
    inst))

(procedure (nvatTbEcfet)
  ; read: 10 mV vsource on In, Out grounded; gate: PWL isource gnd -> IGsc,
  ; 1 G shunt IGsc -> gnd; Rmem net n_rmem.  Mirrors the Gate A deck.
  (let (cv dut vr ig rs g1 g2 g3 g4 p q)
    (setq cv (dbOpenCellViewByType "NVAT_VAL" "tb_ecfet_v3" "schematic" "schematic" "w"))
    (setq dut (nvatInst cv "NVAT_VAL" "ecfet_v3" "I0" (list 0.0 0.0) "R0" nil))
    (setq vr (nvatInst cv "analogLib" "vsource" "V0" (list -2.0 0.0) "R0"
               (list (list "srcType" "string" "dc") (list "vdc" "string" "10m"))))
    (setq ig (nvatInst cv "analogLib" "isource" "I1" (list 0.0 2.0) "R0"
               (list (list "srcType" "string" "pwl") (list "pwlEntryMethod" "string" "File") (list "file_as_var" "boolean" t) (list "fileName" "string" "pwlfile"))))
    (setq rs (nvatInst cv "analogLib" "res" "R1" (list 1.25 1.625) "R0"
               (list (list "r" "string" "1G"))))
    (setq g1 (nvatInst cv "analogLib" "gnd" "G1" (list -2.0 -0.875) "R0" nil))
    (setq g2 (nvatInst cv "analogLib" "gnd" "G2" (list 2.0 -0.875) "R0" nil))
    (setq g3 (nvatInst cv "analogLib" "gnd" "G3" (list 0.0 2.625) "R180" nil))
    (setq g4 (nvatInst cv "analogLib" "gnd" "G4" (list 1.25 0.875) "R0" nil))
    ; In <- V0 plus ; V0 minus -> gnd
    (setq p (nvatTermPt vr "PLUS")) (setq q (nvatTermPt dut "In"))
    (nvatWire cv (list p (list (xCoord p) (yCoord q)) q) "n_in")
    (nvatWire cv (list (nvatTermPt vr "MINUS") (nvatTermPt g1 "gnd!")) nil)
    ; Out -> gnd
    (setq p (nvatTermPt dut "Out")) (setq q (nvatTermPt g2 "gnd!"))
    (nvatWire cv (list p (list (xCoord q) (yCoord p)) q) nil)
    ; gate: I1 MINUS -> IGsc (current from gnd INTO IGsc), I1 PLUS -> gnd
    (setq p (nvatTermPt ig "MINUS")) (setq q (nvatTermPt dut "IGsc"))
    (nvatWire cv (list p q) "n_igsc")
    (nvatWire cv (list (nvatTermPt ig "PLUS") (nvatTermPt g3 "gnd!")) nil)
    ; shunt R1 PLUS -> n_igsc, MINUS -> gnd
    (setq p (nvatTermPt rs "PLUS")) (setq q (list 0.0 (yCoord p)))
    (nvatWire cv (list p q) nil)
    (nvatWire cv (list (nvatTermPt rs "MINUS") (nvatTermPt g4 "gnd!")) nil)
    ; Rmem stub with net label
    (setq p (nvatTermPt dut "Rmem"))
    (nvatWire cv (list p (list (xCoord p) (difference (yCoord p) 0.5))) "n_rmem")
    (schCheck cv)
    (dbSave cv)
    (dbClose cv)
    "OK"))

(procedure (nvatTbRram)
  ; V(TE,BE) PWL vsource, BE grounded.  Mirrors the stanford-1 decks.
  (let (cv dut vs g1 g2 p q)
    (setq cv (dbOpenCellViewByType "NVAT_VAL" "tb_rram" "schematic" "schematic" "w"))
    (setq dut (nvatInst cv "NVAT_VAL" "rram_v_1_0_0" "I0" (list 0.0 0.0) "R0"
                (list (list "model_switch" "int" 0) (list "q" "float" 1.602176462e-19)
                      (list "kb" "float" 1.3806503e-23) (list "time_step" "string" "tstep"))))
    (setq vs (nvatInst cv "analogLib" "vsource" "V0" (list -1.5 0.5) "R0"
               (list (list "srcType" "string" "pwl") (list "pwlEntryMethod" "string" "File") (list "file_as_var" "boolean" t) (list "fileName" "string" "pwlfile"))))
    (setq g1 (nvatInst cv "analogLib" "gnd" "G1" (list -1.5 -0.375) "R0" nil))
    (setq g2 (nvatInst cv "analogLib" "gnd" "G2" (list 0.0 -1.0) "R0" nil))
    (setq p (nvatTermPt vs "PLUS")) (setq q (nvatTermPt dut "TE"))
    (nvatWire cv (list p (list (xCoord p) (plus (yCoord q) 0.25)) (list (xCoord q) (plus (yCoord q) 0.25)) q) "n_te")
    (nvatWire cv (list (nvatTermPt vs "MINUS") (nvatTermPt g1 "gnd!")) nil)
    (nvatWire cv (list (nvatTermPt dut "BE") (nvatTermPt g2 "gnd!")) nil)
    (schCheck cv)
    (dbSave cv)
    (dbClose cv)
    "OK"))
