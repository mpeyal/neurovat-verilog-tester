// stdp_pair_sweep.scs - GENERATED by validation/spice/make_netlists.py; do not edit.
// Gate A validation deck: ecfet_v2 under stimulus 'stdp_pair_sweep'
//   opposite-polarity 50 pA / 10 ms pulse pairs on the single gate pin, onset-to-onset dt = +20/+50/+200/-20/-50/-200 ms, 2 s apart
// stimulus set gateA-1 (12659ad495151485), t_stop 12.51 s
//
// Run (writes stdp_pair_sweep.raw/tran.tran in PSF-ascii):
//   spectre +escchars -format psfascii -raw stdp_pair_sweep.raw +log stdp_pair_sweep.log stdp_pair_sweep.scs
// then import with validation/scrub_spectre.py (see validation/README.md).

simulator lang=spectre
global 0

ahdl_include "../../../../verilog/ecfet_v2.va"

simOpts options reltol=1e-6 vabstol=1e-12 iabstol=1e-18 gmin=1e-15 temp=27
saveOpts options save=selected

// DUT: module ecfet_v2(In, Out, IGsc, Rmem); defaults = Python twin defaults.
// Out is grounded so the In-Out read loop has a reference node.
X1 (n_in 0 n_igsc n_rmem) ecfet_v2

// read path: 10 mV across In-Out; i(vread) = V_read * G
vread (n_in 0) vsource dc=0.01 type=dc

// gate drive: intended so a positive value flows INTO the IGsc pin (potentiation)
igate (0 n_igsc) isource type=pwl wave=[ 0 0 0.01 0 0.010001 -5e-11 0.02 -5e-11 \
    0.020001 0 0.03 0 0.030001 5e-11 0.04 5e-11 \
    0.040001 0 2.01 0 2.010001 -5e-11 2.02 -5e-11 \
    2.020001 0 2.06 0 2.060001 5e-11 2.07 5e-11 \
    2.070001 0 4.01 0 4.010001 -5e-11 4.02 -5e-11 \
    4.020001 0 4.21 0 4.210001 5e-11 4.22 5e-11 \
    4.220001 0 6.01 0 6.010001 5e-11 6.02 5e-11 \
    6.020001 0 6.03 0 6.030001 -5e-11 6.04 -5e-11 \
    6.040001 0 8.01 0 8.010001 5e-11 8.02 5e-11 \
    8.020001 0 8.06 0 8.060001 -5e-11 8.07 -5e-11 \
    8.070001 0 10.01 0 10.010001 5e-11 10.02 5e-11 \
    10.020001 0 10.21 0 10.210001 -5e-11 10.22 -5e-11 \
    10.220001 0 12.51 0 ]
Rshunt (n_igsc 0) resistor r=1G   // DC path for the IGsc sense node

// initial state (n_nv = 1/Rinit (also forced by the .va's analysis("ic") branch))
ic X1.n_nv=0.000227272727273 X1.n_v1=0 X1.n_v2=0 X1.n_v3=0

tran tran stop=12.51 maxstep=0.002 errpreset=conservative ic=node

save n_rmem X1.n_nv X1.n_v1 X1.n_v2 X1.n_v3 X1.n_stdp vread:p X1:IGsc
