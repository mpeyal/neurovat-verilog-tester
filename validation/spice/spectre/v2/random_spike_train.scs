// random_spike_train.scs - GENERATED by validation/spice/make_netlists.py; do not edit.
// Gate A validation deck: ecfet_v2 under stimulus 'random_spike_train'
//   40 seeded random-sign 200 pA / 5 ms spikes, exponential gaps (mean 60 ms)
// stimulus set gateA-1 (12659ad495151485), t_stop 3.13153 s
//
// Run (writes random_spike_train.raw/tran.tran in PSF-ascii):
//   spectre +escchars -format psfascii -raw random_spike_train.raw +log random_spike_train.log random_spike_train.scs
// then import with validation/scrub_spectre.py (see validation/README.md).

simulator lang=spectre
global 0

ahdl_include "../../../../verilog/ecfet_v2.va"

simOpts options reltol=1e-6 vabstol=1e-12 iabstol=1e-18 gmin=1e-15 temp=27
saveOpts options save=selected

// DUT: module ecfet_v2(In, Out, IGsc, Rmem); defaults = Python twin defaults.
// Out is grounded so the In-Out read loop has a reference node.
X1 (n_in 0 n_igsc n_rmem) ecfet_v2

// read path: 10 mV across In-Out; i(vread) = V_read * G
vread (n_in 0) vsource dc=0.01 type=dc

// gate drive: intended so a positive value flows INTO the IGsc pin (potentiation)
igate (0 n_igsc) isource type=pwl wave=[ 0 0 0.01 0 0.010001 2e-10 0.015 2e-10 \
    0.015001 0 0.124763 0 0.124764 2e-10 0.129763 2e-10 \
    0.129764 0 0.192637 0 0.192638 2e-10 0.197637 2e-10 \
    0.197638 0 0.203714 0 0.203715 2e-10 0.208714 2e-10 \
    0.208715 0 0.213692 0 0.213693 2e-10 0.218692 2e-10 \
    0.218693 0 0.227665 0 0.227666 2e-10 0.232665 2e-10 \
    0.232666 0 0.256026 0 0.256027 2e-10 0.261026 2e-10 \
    0.261027 0 0.32648 0 0.326481 -2e-10 0.33148 -2e-10 \
    0.331481 0 0.403095 0 0.403096 -2e-10 0.408095 -2e-10 \
    0.408096 0 0.582133 0 0.582134 -2e-10 0.587133 -2e-10 \
    0.587134 0 0.686123 0 0.686124 2e-10 0.691123 2e-10 \
    0.691124 0 0.779261 0 0.779262 2e-10 0.784261 2e-10 \
    0.784262 0 0.864293 0 0.864294 2e-10 0.869293 2e-10 \
    0.869294 0 0.882174 0 0.882175 -2e-10 0.887174 -2e-10 \
    0.887175 0 0.893633 0 0.893634 2e-10 0.898633 2e-10 \
    0.898634 0 0.996648 0 0.996649 2e-10 1.001648 2e-10 \
    1.001649 0 1.096426 0 1.096427 2e-10 1.101426 2e-10 \
    1.101427 0 1.106499 0 1.1065 2e-10 1.111499 2e-10 \
    1.1115 0 1.193658 0 1.193659 2e-10 1.198658 2e-10 \
    1.198659 0 1.238345 0 1.238346 2e-10 1.243345 2e-10 \
    1.243346 0 1.264643 0 1.264644 2e-10 1.269643 2e-10 \
    1.269644 0 1.281921 0 1.281922 2e-10 1.286921 2e-10 \
    1.286922 0 1.356027 0 1.356028 -2e-10 1.361027 -2e-10 \
    1.361028 0 1.367772 0 1.367773 -2e-10 1.372772 -2e-10 \
    1.372773 0 1.596383 0 1.596384 -2e-10 1.601383 -2e-10 \
    1.601384 0 1.632648 0 1.632649 -2e-10 1.637648 -2e-10 \
    1.637649 0 1.653566 0 1.653567 2e-10 1.658566 2e-10 \
    1.658567 0 1.781061 0 1.781062 -2e-10 1.786061 -2e-10 \
    1.786062 0 1.909231 0 1.909232 -2e-10 1.914231 -2e-10 \
    1.914232 0 1.926442 0 1.926443 -2e-10 1.931442 -2e-10 \
    1.931443 0 2.008335 0 2.008336 2e-10 2.013335 2e-10 \
    2.013336 0 2.090398 0 2.090399 -2e-10 2.095398 -2e-10 \
    2.095399 0 2.101329 0 2.10133 2e-10 2.106329 2e-10 \
    2.10633 0 2.109448 0 2.109449 -2e-10 2.114448 -2e-10 \
    2.114449 0 2.164207 0 2.164208 -2e-10 2.169207 -2e-10 \
    2.169208 0 2.171648 0 2.171649 -2e-10 2.176648 -2e-10 \
    2.176649 0 2.26559 0 2.265591 -2e-10 2.27059 -2e-10 \
    2.270591 0 2.386518 0 2.386519 -2e-10 2.391518 -2e-10 \
    2.391519 0 2.402239 0 2.40224 -2e-10 2.407239 -2e-10 \
    2.40724 0 2.626535 0 2.626536 2e-10 2.631535 2e-10 \
    2.631536 0 3.131535 0 ]
Rshunt (n_igsc 0) resistor r=1G   // DC path for the IGsc sense node

// initial state (n_nv = 1/Rinit (also forced by the .va's analysis("ic") branch))
ic X1.n_nv=0.000227272727273 X1.n_v1=0 X1.n_v2=0 X1.n_v3=0

tran tran stop=3.131535 maxstep=0.001 errpreset=conservative ic=node

save n_rmem X1.n_nv X1.n_v1 X1.n_v2 X1.n_v3 X1.n_stdp vread:p X1:IGsc
