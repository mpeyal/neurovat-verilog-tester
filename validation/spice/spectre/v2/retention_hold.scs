// retention_hold.scs - GENERATED by validation/spice/make_netlists.py; do not edit.
// Gate A validation deck: ecfet_v2 under stimulus 'retention_hold'
//   10 x +500 pA / 10 ms programming, then hold (no drive) to 20 s
// stimulus set gateA-1 (12659ad495151485), t_stop 20 s
//
// Run (writes retention_hold.raw/tran.tran in PSF-ascii):
//   spectre +escchars -format psfascii -raw retention_hold.raw +log retention_hold.log retention_hold.scs
// then import with validation/scrub_spectre.py (see validation/README.md).

simulator lang=spectre
global 0

ahdl_include "../../../../verilog/ecfet_v2.va"

simOpts options reltol=1e-6 vabstol=1e-12 iabstol=1e-18 gmin=1e-15 temp=27
saveOpts options save=selected

// DUT: module ecfet_v2(In, Out, IGsc, Rmem); defaults = Python twin defaults.
// Out is grounded so the In-Out read loop has a reference node.
X1 (n_in 0 n_igsc n_rmem) ecfet_v2

// read path: 10 mV across In-Out; i(vread) = V_read * G
vread (n_in 0) vsource dc=0.01 type=dc

// gate drive: intended so a positive value flows INTO the IGsc pin (potentiation)
igate (0 n_igsc) isource type=pwl wave=[ 0 0 0.01 0 0.010001 5e-10 0.02 5e-10 \
    0.020001 0 0.06 0 0.060001 5e-10 0.07 5e-10 \
    0.070001 0 0.11 0 0.110001 5e-10 0.12 5e-10 \
    0.120001 0 0.16 0 0.160001 5e-10 0.17 5e-10 \
    0.170001 0 0.21 0 0.210001 5e-10 0.22 5e-10 \
    0.220001 0 0.26 0 0.260001 5e-10 0.27 5e-10 \
    0.270001 0 0.31 0 0.310001 5e-10 0.32 5e-10 \
    0.320001 0 0.36 0 0.360001 5e-10 0.37 5e-10 \
    0.370001 0 0.41 0 0.410001 5e-10 0.42 5e-10 \
    0.420001 0 0.46 0 0.460001 5e-10 0.47 5e-10 \
    0.470001 0 20 0 ]
Rshunt (n_igsc 0) resistor r=1G   // DC path for the IGsc sense node

// initial state (n_nv = 1/Rinit (also forced by the .va's analysis("ic") branch))
ic X1.n_nv=0.000227272727273 X1.n_v1=0 X1.n_v2=0 X1.n_v3=0

tran tran stop=20 maxstep=0.005 errpreset=conservative ic=node

save n_rmem X1.n_nv X1.n_v1 X1.n_v2 X1.n_v3 X1.n_stdp vread:p X1:IGsc
