// ltp_ltd.scs - GENERATED by validation/paper/make_decks_paper.py; do not edit.
// Paper overlay deck (Sharbati et al., Adv. Mater. 30, 1802353 (2018)): ecfet_v2 under 'ltp_ltd'
//   400 x -50 pA (to the low rail), 1700 x +50 pA (LTP), 1700 x -50 pA (LTD); 10 ms every 50 ms (Fig. 3c)
// stimulus set sharbati-1 (d133e46493727894), t_stop 190.6 s
//
// Run (writes ltp_ltd.raw/tran.tran in PSF-ascii):
//   spectre +escchars -format psfascii -raw ltp_ltd.raw +log ltp_ltd.log ltp_ltd.scs
// then import with validation/paper/scrub_paper.py (see validation/README.md).

simulator lang=spectre
global 0

ahdl_include "../../../../verilog/ecfet_v2.va"

simOpts options reltol=1e-6 vabstol=1e-12 iabstol=1e-18 gmin=1e-15 temp=27
saveOpts options save=selected

// DUT: module ecfet_v2(In, Out, IGsc, Rmem); defaults = Python twin defaults.
X1 (n_in 0 n_igsc n_rmem) ecfet_v2

// read path: 10 mV across In-Out (the paper reads at 0.1 V; the
// models' state does not depend on the read bias)
vread (n_in 0) vsource dc=0.01 type=dc

// gate drive: intended so a positive value flows INTO the IGsc pin (potentiation)
igate (0 n_igsc) isource type=pwl wave=[ 0 0 0.1 0 0.100001 -5e-11 0.11 -5e-11 \
    0.110001 0 0.15 0 0.150001 -5e-11 0.16 -5e-11 \
    0.160001 0 0.2 0 0.200001 -5e-11 0.21 -5e-11 \
    0.210001 0 0.25 0 0.250001 -5e-11 0.26 -5e-11 \
    0.260001 0 0.3 0 0.300001 -5e-11 0.31 -5e-11 \
    0.310001 0 0.35 0 0.350001 -5e-11 0.36 -5e-11 \
    0.360001 0 0.4 0 0.400001 -5e-11 0.41 -5e-11 \
    0.410001 0 0.45 0 0.450001 -5e-11 0.46 -5e-11 \
    0.460001 0 0.5 0 0.500001 -5e-11 0.51 -5e-11 \
    0.510001 0 0.55 0 0.550001 -5e-11 0.56 -5e-11 \
    0.560001 0 0.6 0 0.600001 -5e-11 0.61 -5e-11 \
    0.610001 0 0.65 0 0.650001 -5e-11 0.66 -5e-11 \
    0.660001 0 0.7 0 0.700001 -5e-11 0.71 -5e-11 \
    0.710001 0 0.75 0 0.750001 -5e-11 0.76 -5e-11 \
    0.760001 0 0.8 0 0.800001 -5e-11 0.81 -5e-11 \
    0.810001 0 0.85 0 0.850001 -5e-11 0.86 -5e-11 \
    0.860001 0 0.9 0 0.900001 -5e-11 0.91 -5e-11 \
    0.910001 0 0.95 0 0.950001 -5e-11 0.96 -5e-11 \
    0.960001 0 1 0 1.000001 -5e-11 1.01 -5e-11 \
    1.010001 0 1.05 0 1.050001 -5e-11 1.06 -5e-11 \
    1.060001 0 1.1 0 1.100001 -5e-11 1.11 -5e-11 \
    1.110001 0 1.15 0 1.150001 -5e-11 1.16 -5e-11 \
    1.160001 0 1.2 0 1.200001 -5e-11 1.21 -5e-11 \
    1.210001 0 1.25 0 1.250001 -5e-11 1.26 -5e-11 \
    1.260001 0 1.3 0 1.300001 -5e-11 1.31 -5e-11 \
    1.310001 0 1.35 0 1.350001 -5e-11 1.36 -5e-11 \
    1.360001 0 1.4 0 1.400001 -5e-11 1.41 -5e-11 \
    1.410001 0 1.45 0 1.450001 -5e-11 1.46 -5e-11 \
    1.460001 0 1.5 0 1.500001 -5e-11 1.51 -5e-11 \
    1.510001 0 1.55 0 1.550001 -5e-11 1.56 -5e-11 \
    1.560001 0 1.6 0 1.600001 -5e-11 1.61 -5e-11 \
    1.610001 0 1.65 0 1.650001 -5e-11 1.66 -5e-11 \
    1.660001 0 1.7 0 1.700001 -5e-11 1.71 -5e-11 \
    1.710001 0 1.75 0 1.750001 -5e-11 1.76 -5e-11 \
    1.760001 0 1.8 0 1.800001 -5e-11 1.81 -5e-11 \
    1.810001 0 1.85 0 1.850001 -5e-11 1.86 -5e-11 \
    1.860001 0 1.9 0 1.900001 -5e-11 1.91 -5e-11 \
    1.910001 0 1.95 0 1.950001 -5e-11 1.96 -5e-11 \
    1.960001 0 2 0 2.000001 -5e-11 2.01 -5e-11 \
    2.010001 0 2.05 0 2.050001 -5e-11 2.06 -5e-11 \
    2.060001 0 2.1 0 2.100001 -5e-11 2.11 -5e-11 \
    2.110001 0 2.15 0 2.150001 -5e-11 2.16 -5e-11 \
    2.160001 0 2.2 0 2.200001 -5e-11 2.21 -5e-11 \
    2.210001 0 2.25 0 2.250001 -5e-11 2.26 -5e-11 \
    2.260001 0 2.3 0 2.300001 -5e-11 2.31 -5e-11 \
    2.310001 0 2.35 0 2.350001 -5e-11 2.36 -5e-11 \
    2.360001 0 2.4 0 2.400001 -5e-11 2.41 -5e-11 \
    2.410001 0 2.45 0 2.450001 -5e-11 2.46 -5e-11 \
    2.460001 0 2.5 0 2.500001 -5e-11 2.51 -5e-11 \
    2.510001 0 2.55 0 2.550001 -5e-11 2.56 -5e-11 \
    2.560001 0 2.6 0 2.600001 -5e-11 2.61 -5e-11 \
    2.610001 0 2.65 0 2.650001 -5e-11 2.66 -5e-11 \
    2.660001 0 2.7 0 2.700001 -5e-11 2.71 -5e-11 \
    2.710001 0 2.75 0 2.750001 -5e-11 2.76 -5e-11 \
    2.760001 0 2.8 0 2.800001 -5e-11 2.81 -5e-11 \
    2.810001 0 2.85 0 2.850001 -5e-11 2.86 -5e-11 \
    2.860001 0 2.9 0 2.900001 -5e-11 2.91 -5e-11 \
    2.910001 0 2.95 0 2.950001 -5e-11 2.96 -5e-11 \
    2.960001 0 3 0 3.000001 -5e-11 3.01 -5e-11 \
    3.010001 0 3.05 0 3.050001 -5e-11 3.06 -5e-11 \
    3.060001 0 3.1 0 3.100001 -5e-11 3.11 -5e-11 \
    3.110001 0 3.15 0 3.150001 -5e-11 3.16 -5e-11 \
    3.160001 0 3.2 0 3.200001 -5e-11 3.21 -5e-11 \
    3.210001 0 3.25 0 3.250001 -5e-11 3.26 -5e-11 \
    3.260001 0 3.3 0 3.300001 -5e-11 3.31 -5e-11 \
    3.310001 0 3.35 0 3.350001 -5e-11 3.36 -5e-11 \
    3.360001 0 3.4 0 3.400001 -5e-11 3.41 -5e-11 \
    3.410001 0 3.45 0 3.450001 -5e-11 3.46 -5e-11 \
    3.460001 0 3.5 0 3.500001 -5e-11 3.51 -5e-11 \
    3.510001 0 3.55 0 3.550001 -5e-11 3.56 -5e-11 \
    3.560001 0 3.6 0 3.600001 -5e-11 3.61 -5e-11 \
    3.610001 0 3.65 0 3.650001 -5e-11 3.66 -5e-11 \
    3.660001 0 3.7 0 3.700001 -5e-11 3.71 -5e-11 \
    3.710001 0 3.75 0 3.750001 -5e-11 3.76 -5e-11 \
    3.760001 0 3.8 0 3.800001 -5e-11 3.81 -5e-11 \
    3.810001 0 3.85 0 3.850001 -5e-11 3.86 -5e-11 \
    3.860001 0 3.9 0 3.900001 -5e-11 3.91 -5e-11 \
    3.910001 0 3.95 0 3.950001 -5e-11 3.96 -5e-11 \
    3.960001 0 4 0 4.000001 -5e-11 4.01 -5e-11 \
    4.010001 0 4.05 0 4.050001 -5e-11 4.06 -5e-11 \
    4.060001 0 4.1 0 4.100001 -5e-11 4.11 -5e-11 \
    4.110001 0 4.15 0 4.150001 -5e-11 4.16 -5e-11 \
    4.160001 0 4.2 0 4.200001 -5e-11 4.21 -5e-11 \
    4.210001 0 4.25 0 4.250001 -5e-11 4.26 -5e-11 \
    4.260001 0 4.3 0 4.300001 -5e-11 4.31 -5e-11 \
    4.310001 0 4.35 0 4.350001 -5e-11 4.36 -5e-11 \
    4.360001 0 4.4 0 4.400001 -5e-11 4.41 -5e-11 \
    4.410001 0 4.45 0 4.450001 -5e-11 4.46 -5e-11 \
    4.460001 0 4.5 0 4.500001 -5e-11 4.51 -5e-11 \
    4.510001 0 4.55 0 4.550001 -5e-11 4.56 -5e-11 \
    4.560001 0 4.6 0 4.600001 -5e-11 4.61 -5e-11 \
    4.610001 0 4.65 0 4.650001 -5e-11 4.66 -5e-11 \
    4.660001 0 4.7 0 4.700001 -5e-11 4.71 -5e-11 \
    4.710001 0 4.75 0 4.750001 -5e-11 4.76 -5e-11 \
    4.760001 0 4.8 0 4.800001 -5e-11 4.81 -5e-11 \
    4.810001 0 4.85 0 4.850001 -5e-11 4.86 -5e-11 \
    4.860001 0 4.9 0 4.900001 -5e-11 4.91 -5e-11 \
    4.910001 0 4.95 0 4.950001 -5e-11 4.96 -5e-11 \
    4.960001 0 5 0 5.000001 -5e-11 5.01 -5e-11 \
    5.010001 0 5.05 0 5.050001 -5e-11 5.06 -5e-11 \
    5.060001 0 5.1 0 5.100001 -5e-11 5.11 -5e-11 \
    5.110001 0 5.15 0 5.150001 -5e-11 5.16 -5e-11 \
    5.160001 0 5.2 0 5.200001 -5e-11 5.21 -5e-11 \
    5.210001 0 5.25 0 5.250001 -5e-11 5.26 -5e-11 \
    5.260001 0 5.3 0 5.300001 -5e-11 5.31 -5e-11 \
    5.310001 0 5.35 0 5.350001 -5e-11 5.36 -5e-11 \
    5.360001 0 5.4 0 5.400001 -5e-11 5.41 -5e-11 \
    5.410001 0 5.45 0 5.450001 -5e-11 5.46 -5e-11 \
    5.460001 0 5.5 0 5.500001 -5e-11 5.51 -5e-11 \
    5.510001 0 5.55 0 5.550001 -5e-11 5.56 -5e-11 \
    5.560001 0 5.6 0 5.600001 -5e-11 5.61 -5e-11 \
    5.610001 0 5.65 0 5.650001 -5e-11 5.66 -5e-11 \
    5.660001 0 5.7 0 5.700001 -5e-11 5.71 -5e-11 \
    5.710001 0 5.75 0 5.750001 -5e-11 5.76 -5e-11 \
    5.760001 0 5.8 0 5.800001 -5e-11 5.81 -5e-11 \
    5.810001 0 5.85 0 5.850001 -5e-11 5.86 -5e-11 \
    5.860001 0 5.9 0 5.900001 -5e-11 5.91 -5e-11 \
    5.910001 0 5.95 0 5.950001 -5e-11 5.96 -5e-11 \
    5.960001 0 6 0 6.000001 -5e-11 6.01 -5e-11 \
    6.010001 0 6.05 0 6.050001 -5e-11 6.06 -5e-11 \
    6.060001 0 6.1 0 6.100001 -5e-11 6.11 -5e-11 \
    6.110001 0 6.15 0 6.150001 -5e-11 6.16 -5e-11 \
    6.160001 0 6.2 0 6.200001 -5e-11 6.21 -5e-11 \
    6.210001 0 6.25 0 6.250001 -5e-11 6.26 -5e-11 \
    6.260001 0 6.3 0 6.300001 -5e-11 6.31 -5e-11 \
    6.310001 0 6.35 0 6.350001 -5e-11 6.36 -5e-11 \
    6.360001 0 6.4 0 6.400001 -5e-11 6.41 -5e-11 \
    6.410001 0 6.45 0 6.450001 -5e-11 6.46 -5e-11 \
    6.460001 0 6.5 0 6.500001 -5e-11 6.51 -5e-11 \
    6.510001 0 6.55 0 6.550001 -5e-11 6.56 -5e-11 \
    6.560001 0 6.6 0 6.600001 -5e-11 6.61 -5e-11 \
    6.610001 0 6.65 0 6.650001 -5e-11 6.66 -5e-11 \
    6.660001 0 6.7 0 6.700001 -5e-11 6.71 -5e-11 \
    6.710001 0 6.75 0 6.750001 -5e-11 6.76 -5e-11 \
    6.760001 0 6.8 0 6.800001 -5e-11 6.81 -5e-11 \
    6.810001 0 6.85 0 6.850001 -5e-11 6.86 -5e-11 \
    6.860001 0 6.9 0 6.900001 -5e-11 6.91 -5e-11 \
    6.910001 0 6.95 0 6.950001 -5e-11 6.96 -5e-11 \
    6.960001 0 7 0 7.000001 -5e-11 7.01 -5e-11 \
    7.010001 0 7.05 0 7.050001 -5e-11 7.06 -5e-11 \
    7.060001 0 7.1 0 7.100001 -5e-11 7.11 -5e-11 \
    7.110001 0 7.15 0 7.150001 -5e-11 7.16 -5e-11 \
    7.160001 0 7.2 0 7.200001 -5e-11 7.21 -5e-11 \
    7.210001 0 7.25 0 7.250001 -5e-11 7.26 -5e-11 \
    7.260001 0 7.3 0 7.300001 -5e-11 7.31 -5e-11 \
    7.310001 0 7.35 0 7.350001 -5e-11 7.36 -5e-11 \
    7.360001 0 7.4 0 7.400001 -5e-11 7.41 -5e-11 \
    7.410001 0 7.45 0 7.450001 -5e-11 7.46 -5e-11 \
    7.460001 0 7.5 0 7.500001 -5e-11 7.51 -5e-11 \
    7.510001 0 7.55 0 7.550001 -5e-11 7.56 -5e-11 \
    7.560001 0 7.6 0 7.600001 -5e-11 7.61 -5e-11 \
    7.610001 0 7.65 0 7.650001 -5e-11 7.66 -5e-11 \
    7.660001 0 7.7 0 7.700001 -5e-11 7.71 -5e-11 \
    7.710001 0 7.75 0 7.750001 -5e-11 7.76 -5e-11 \
    7.760001 0 7.8 0 7.800001 -5e-11 7.81 -5e-11 \
    7.810001 0 7.85 0 7.850001 -5e-11 7.86 -5e-11 \
    7.860001 0 7.9 0 7.900001 -5e-11 7.91 -5e-11 \
    7.910001 0 7.95 0 7.950001 -5e-11 7.96 -5e-11 \
    7.960001 0 8 0 8.000001 -5e-11 8.01 -5e-11 \
    8.010001 0 8.05 0 8.050001 -5e-11 8.06 -5e-11 \
    8.060001 0 8.1 0 8.100001 -5e-11 8.11 -5e-11 \
    8.110001 0 8.15 0 8.150001 -5e-11 8.16 -5e-11 \
    8.160001 0 8.2 0 8.200001 -5e-11 8.21 -5e-11 \
    8.210001 0 8.25 0 8.250001 -5e-11 8.26 -5e-11 \
    8.260001 0 8.3 0 8.300001 -5e-11 8.31 -5e-11 \
    8.310001 0 8.35 0 8.350001 -5e-11 8.36 -5e-11 \
    8.360001 0 8.4 0 8.400001 -5e-11 8.41 -5e-11 \
    8.410001 0 8.45 0 8.450001 -5e-11 8.46 -5e-11 \
    8.460001 0 8.5 0 8.500001 -5e-11 8.51 -5e-11 \
    8.510001 0 8.55 0 8.550001 -5e-11 8.56 -5e-11 \
    8.560001 0 8.6 0 8.600001 -5e-11 8.61 -5e-11 \
    8.610001 0 8.65 0 8.650001 -5e-11 8.66 -5e-11 \
    8.660001 0 8.7 0 8.700001 -5e-11 8.71 -5e-11 \
    8.710001 0 8.75 0 8.750001 -5e-11 8.76 -5e-11 \
    8.760001 0 8.8 0 8.800001 -5e-11 8.81 -5e-11 \
    8.810001 0 8.85 0 8.850001 -5e-11 8.86 -5e-11 \
    8.860001 0 8.9 0 8.900001 -5e-11 8.91 -5e-11 \
    8.910001 0 8.95 0 8.950001 -5e-11 8.96 -5e-11 \
    8.960001 0 9 0 9.000001 -5e-11 9.01 -5e-11 \
    9.010001 0 9.05 0 9.050001 -5e-11 9.06 -5e-11 \
    9.060001 0 9.1 0 9.100001 -5e-11 9.11 -5e-11 \
    9.110001 0 9.15 0 9.150001 -5e-11 9.16 -5e-11 \
    9.160001 0 9.2 0 9.200001 -5e-11 9.21 -5e-11 \
    9.210001 0 9.25 0 9.250001 -5e-11 9.26 -5e-11 \
    9.260001 0 9.3 0 9.300001 -5e-11 9.31 -5e-11 \
    9.310001 0 9.35 0 9.350001 -5e-11 9.36 -5e-11 \
    9.360001 0 9.4 0 9.400001 -5e-11 9.41 -5e-11 \
    9.410001 0 9.45 0 9.450001 -5e-11 9.46 -5e-11 \
    9.460001 0 9.5 0 9.500001 -5e-11 9.51 -5e-11 \
    9.510001 0 9.55 0 9.550001 -5e-11 9.56 -5e-11 \
    9.560001 0 9.6 0 9.600001 -5e-11 9.61 -5e-11 \
    9.610001 0 9.65 0 9.650001 -5e-11 9.66 -5e-11 \
    9.660001 0 9.7 0 9.700001 -5e-11 9.71 -5e-11 \
    9.710001 0 9.75 0 9.750001 -5e-11 9.76 -5e-11 \
    9.760001 0 9.8 0 9.800001 -5e-11 9.81 -5e-11 \
    9.810001 0 9.85 0 9.850001 -5e-11 9.86 -5e-11 \
    9.860001 0 9.9 0 9.900001 -5e-11 9.91 -5e-11 \
    9.910001 0 9.95 0 9.950001 -5e-11 9.96 -5e-11 \
    9.960001 0 10 0 10.000001 -5e-11 10.01 -5e-11 \
    10.010001 0 10.05 0 10.050001 -5e-11 10.06 -5e-11 \
    10.060001 0 10.1 0 10.100001 -5e-11 10.11 -5e-11 \
    10.110001 0 10.15 0 10.150001 -5e-11 10.16 -5e-11 \
    10.160001 0 10.2 0 10.200001 -5e-11 10.21 -5e-11 \
    10.210001 0 10.25 0 10.250001 -5e-11 10.26 -5e-11 \
    10.260001 0 10.3 0 10.300001 -5e-11 10.31 -5e-11 \
    10.310001 0 10.35 0 10.350001 -5e-11 10.36 -5e-11 \
    10.360001 0 10.4 0 10.400001 -5e-11 10.41 -5e-11 \
    10.410001 0 10.45 0 10.450001 -5e-11 10.46 -5e-11 \
    10.460001 0 10.5 0 10.500001 -5e-11 10.51 -5e-11 \
    10.510001 0 10.55 0 10.550001 -5e-11 10.56 -5e-11 \
    10.560001 0 10.6 0 10.600001 -5e-11 10.61 -5e-11 \
    10.610001 0 10.65 0 10.650001 -5e-11 10.66 -5e-11 \
    10.660001 0 10.7 0 10.700001 -5e-11 10.71 -5e-11 \
    10.710001 0 10.75 0 10.750001 -5e-11 10.76 -5e-11 \
    10.760001 0 10.8 0 10.800001 -5e-11 10.81 -5e-11 \
    10.810001 0 10.85 0 10.850001 -5e-11 10.86 -5e-11 \
    10.860001 0 10.9 0 10.900001 -5e-11 10.91 -5e-11 \
    10.910001 0 10.95 0 10.950001 -5e-11 10.96 -5e-11 \
    10.960001 0 11 0 11.000001 -5e-11 11.01 -5e-11 \
    11.010001 0 11.05 0 11.050001 -5e-11 11.06 -5e-11 \
    11.060001 0 11.1 0 11.100001 -5e-11 11.11 -5e-11 \
    11.110001 0 11.15 0 11.150001 -5e-11 11.16 -5e-11 \
    11.160001 0 11.2 0 11.200001 -5e-11 11.21 -5e-11 \
    11.210001 0 11.25 0 11.250001 -5e-11 11.26 -5e-11 \
    11.260001 0 11.3 0 11.300001 -5e-11 11.31 -5e-11 \
    11.310001 0 11.35 0 11.350001 -5e-11 11.36 -5e-11 \
    11.360001 0 11.4 0 11.400001 -5e-11 11.41 -5e-11 \
    11.410001 0 11.45 0 11.450001 -5e-11 11.46 -5e-11 \
    11.460001 0 11.5 0 11.500001 -5e-11 11.51 -5e-11 \
    11.510001 0 11.55 0 11.550001 -5e-11 11.56 -5e-11 \
    11.560001 0 11.6 0 11.600001 -5e-11 11.61 -5e-11 \
    11.610001 0 11.65 0 11.650001 -5e-11 11.66 -5e-11 \
    11.660001 0 11.7 0 11.700001 -5e-11 11.71 -5e-11 \
    11.710001 0 11.75 0 11.750001 -5e-11 11.76 -5e-11 \
    11.760001 0 11.8 0 11.800001 -5e-11 11.81 -5e-11 \
    11.810001 0 11.85 0 11.850001 -5e-11 11.86 -5e-11 \
    11.860001 0 11.9 0 11.900001 -5e-11 11.91 -5e-11 \
    11.910001 0 11.95 0 11.950001 -5e-11 11.96 -5e-11 \
    11.960001 0 12 0 12.000001 -5e-11 12.01 -5e-11 \
    12.010001 0 12.05 0 12.050001 -5e-11 12.06 -5e-11 \
    12.060001 0 12.1 0 12.100001 -5e-11 12.11 -5e-11 \
    12.110001 0 12.15 0 12.150001 -5e-11 12.16 -5e-11 \
    12.160001 0 12.2 0 12.200001 -5e-11 12.21 -5e-11 \
    12.210001 0 12.25 0 12.250001 -5e-11 12.26 -5e-11 \
    12.260001 0 12.3 0 12.300001 -5e-11 12.31 -5e-11 \
    12.310001 0 12.35 0 12.350001 -5e-11 12.36 -5e-11 \
    12.360001 0 12.4 0 12.400001 -5e-11 12.41 -5e-11 \
    12.410001 0 12.45 0 12.450001 -5e-11 12.46 -5e-11 \
    12.460001 0 12.5 0 12.500001 -5e-11 12.51 -5e-11 \
    12.510001 0 12.55 0 12.550001 -5e-11 12.56 -5e-11 \
    12.560001 0 12.6 0 12.600001 -5e-11 12.61 -5e-11 \
    12.610001 0 12.65 0 12.650001 -5e-11 12.66 -5e-11 \
    12.660001 0 12.7 0 12.700001 -5e-11 12.71 -5e-11 \
    12.710001 0 12.75 0 12.750001 -5e-11 12.76 -5e-11 \
    12.760001 0 12.8 0 12.800001 -5e-11 12.81 -5e-11 \
    12.810001 0 12.85 0 12.850001 -5e-11 12.86 -5e-11 \
    12.860001 0 12.9 0 12.900001 -5e-11 12.91 -5e-11 \
    12.910001 0 12.95 0 12.950001 -5e-11 12.96 -5e-11 \
    12.960001 0 13 0 13.000001 -5e-11 13.01 -5e-11 \
    13.010001 0 13.05 0 13.050001 -5e-11 13.06 -5e-11 \
    13.060001 0 13.1 0 13.100001 -5e-11 13.11 -5e-11 \
    13.110001 0 13.15 0 13.150001 -5e-11 13.16 -5e-11 \
    13.160001 0 13.2 0 13.200001 -5e-11 13.21 -5e-11 \
    13.210001 0 13.25 0 13.250001 -5e-11 13.26 -5e-11 \
    13.260001 0 13.3 0 13.300001 -5e-11 13.31 -5e-11 \
    13.310001 0 13.35 0 13.350001 -5e-11 13.36 -5e-11 \
    13.360001 0 13.4 0 13.400001 -5e-11 13.41 -5e-11 \
    13.410001 0 13.45 0 13.450001 -5e-11 13.46 -5e-11 \
    13.460001 0 13.5 0 13.500001 -5e-11 13.51 -5e-11 \
    13.510001 0 13.55 0 13.550001 -5e-11 13.56 -5e-11 \
    13.560001 0 13.6 0 13.600001 -5e-11 13.61 -5e-11 \
    13.610001 0 13.65 0 13.650001 -5e-11 13.66 -5e-11 \
    13.660001 0 13.7 0 13.700001 -5e-11 13.71 -5e-11 \
    13.710001 0 13.75 0 13.750001 -5e-11 13.76 -5e-11 \
    13.760001 0 13.8 0 13.800001 -5e-11 13.81 -5e-11 \
    13.810001 0 13.85 0 13.850001 -5e-11 13.86 -5e-11 \
    13.860001 0 13.9 0 13.900001 -5e-11 13.91 -5e-11 \
    13.910001 0 13.95 0 13.950001 -5e-11 13.96 -5e-11 \
    13.960001 0 14 0 14.000001 -5e-11 14.01 -5e-11 \
    14.010001 0 14.05 0 14.050001 -5e-11 14.06 -5e-11 \
    14.060001 0 14.1 0 14.100001 -5e-11 14.11 -5e-11 \
    14.110001 0 14.15 0 14.150001 -5e-11 14.16 -5e-11 \
    14.160001 0 14.2 0 14.200001 -5e-11 14.21 -5e-11 \
    14.210001 0 14.25 0 14.250001 -5e-11 14.26 -5e-11 \
    14.260001 0 14.3 0 14.300001 -5e-11 14.31 -5e-11 \
    14.310001 0 14.35 0 14.350001 -5e-11 14.36 -5e-11 \
    14.360001 0 14.4 0 14.400001 -5e-11 14.41 -5e-11 \
    14.410001 0 14.45 0 14.450001 -5e-11 14.46 -5e-11 \
    14.460001 0 14.5 0 14.500001 -5e-11 14.51 -5e-11 \
    14.510001 0 14.55 0 14.550001 -5e-11 14.56 -5e-11 \
    14.560001 0 14.6 0 14.600001 -5e-11 14.61 -5e-11 \
    14.610001 0 14.65 0 14.650001 -5e-11 14.66 -5e-11 \
    14.660001 0 14.7 0 14.700001 -5e-11 14.71 -5e-11 \
    14.710001 0 14.75 0 14.750001 -5e-11 14.76 -5e-11 \
    14.760001 0 14.8 0 14.800001 -5e-11 14.81 -5e-11 \
    14.810001 0 14.85 0 14.850001 -5e-11 14.86 -5e-11 \
    14.860001 0 14.9 0 14.900001 -5e-11 14.91 -5e-11 \
    14.910001 0 14.95 0 14.950001 -5e-11 14.96 -5e-11 \
    14.960001 0 15 0 15.000001 -5e-11 15.01 -5e-11 \
    15.010001 0 15.05 0 15.050001 -5e-11 15.06 -5e-11 \
    15.060001 0 15.1 0 15.100001 -5e-11 15.11 -5e-11 \
    15.110001 0 15.15 0 15.150001 -5e-11 15.16 -5e-11 \
    15.160001 0 15.2 0 15.200001 -5e-11 15.21 -5e-11 \
    15.210001 0 15.25 0 15.250001 -5e-11 15.26 -5e-11 \
    15.260001 0 15.3 0 15.300001 -5e-11 15.31 -5e-11 \
    15.310001 0 15.35 0 15.350001 -5e-11 15.36 -5e-11 \
    15.360001 0 15.4 0 15.400001 -5e-11 15.41 -5e-11 \
    15.410001 0 15.45 0 15.450001 -5e-11 15.46 -5e-11 \
    15.460001 0 15.5 0 15.500001 -5e-11 15.51 -5e-11 \
    15.510001 0 15.55 0 15.550001 -5e-11 15.56 -5e-11 \
    15.560001 0 15.6 0 15.600001 -5e-11 15.61 -5e-11 \
    15.610001 0 15.65 0 15.650001 -5e-11 15.66 -5e-11 \
    15.660001 0 15.7 0 15.700001 -5e-11 15.71 -5e-11 \
    15.710001 0 15.75 0 15.750001 -5e-11 15.76 -5e-11 \
    15.760001 0 15.8 0 15.800001 -5e-11 15.81 -5e-11 \
    15.810001 0 15.85 0 15.850001 -5e-11 15.86 -5e-11 \
    15.860001 0 15.9 0 15.900001 -5e-11 15.91 -5e-11 \
    15.910001 0 15.95 0 15.950001 -5e-11 15.96 -5e-11 \
    15.960001 0 16 0 16.000001 -5e-11 16.01 -5e-11 \
    16.010001 0 16.05 0 16.050001 -5e-11 16.06 -5e-11 \
    16.060001 0 16.1 0 16.100001 -5e-11 16.11 -5e-11 \
    16.110001 0 16.15 0 16.150001 -5e-11 16.16 -5e-11 \
    16.160001 0 16.2 0 16.200001 -5e-11 16.21 -5e-11 \
    16.210001 0 16.25 0 16.250001 -5e-11 16.26 -5e-11 \
    16.260001 0 16.3 0 16.300001 -5e-11 16.31 -5e-11 \
    16.310001 0 16.35 0 16.350001 -5e-11 16.36 -5e-11 \
    16.360001 0 16.4 0 16.400001 -5e-11 16.41 -5e-11 \
    16.410001 0 16.45 0 16.450001 -5e-11 16.46 -5e-11 \
    16.460001 0 16.5 0 16.500001 -5e-11 16.51 -5e-11 \
    16.510001 0 16.55 0 16.550001 -5e-11 16.56 -5e-11 \
    16.560001 0 16.6 0 16.600001 -5e-11 16.61 -5e-11 \
    16.610001 0 16.65 0 16.650001 -5e-11 16.66 -5e-11 \
    16.660001 0 16.7 0 16.700001 -5e-11 16.71 -5e-11 \
    16.710001 0 16.75 0 16.750001 -5e-11 16.76 -5e-11 \
    16.760001 0 16.8 0 16.800001 -5e-11 16.81 -5e-11 \
    16.810001 0 16.85 0 16.850001 -5e-11 16.86 -5e-11 \
    16.860001 0 16.9 0 16.900001 -5e-11 16.91 -5e-11 \
    16.910001 0 16.95 0 16.950001 -5e-11 16.96 -5e-11 \
    16.960001 0 17 0 17.000001 -5e-11 17.01 -5e-11 \
    17.010001 0 17.05 0 17.050001 -5e-11 17.06 -5e-11 \
    17.060001 0 17.1 0 17.100001 -5e-11 17.11 -5e-11 \
    17.110001 0 17.15 0 17.150001 -5e-11 17.16 -5e-11 \
    17.160001 0 17.2 0 17.200001 -5e-11 17.21 -5e-11 \
    17.210001 0 17.25 0 17.250001 -5e-11 17.26 -5e-11 \
    17.260001 0 17.3 0 17.300001 -5e-11 17.31 -5e-11 \
    17.310001 0 17.35 0 17.350001 -5e-11 17.36 -5e-11 \
    17.360001 0 17.4 0 17.400001 -5e-11 17.41 -5e-11 \
    17.410001 0 17.45 0 17.450001 -5e-11 17.46 -5e-11 \
    17.460001 0 17.5 0 17.500001 -5e-11 17.51 -5e-11 \
    17.510001 0 17.55 0 17.550001 -5e-11 17.56 -5e-11 \
    17.560001 0 17.6 0 17.600001 -5e-11 17.61 -5e-11 \
    17.610001 0 17.65 0 17.650001 -5e-11 17.66 -5e-11 \
    17.660001 0 17.7 0 17.700001 -5e-11 17.71 -5e-11 \
    17.710001 0 17.75 0 17.750001 -5e-11 17.76 -5e-11 \
    17.760001 0 17.8 0 17.800001 -5e-11 17.81 -5e-11 \
    17.810001 0 17.85 0 17.850001 -5e-11 17.86 -5e-11 \
    17.860001 0 17.9 0 17.900001 -5e-11 17.91 -5e-11 \
    17.910001 0 17.95 0 17.950001 -5e-11 17.96 -5e-11 \
    17.960001 0 18 0 18.000001 -5e-11 18.01 -5e-11 \
    18.010001 0 18.05 0 18.050001 -5e-11 18.06 -5e-11 \
    18.060001 0 18.1 0 18.100001 -5e-11 18.11 -5e-11 \
    18.110001 0 18.15 0 18.150001 -5e-11 18.16 -5e-11 \
    18.160001 0 18.2 0 18.200001 -5e-11 18.21 -5e-11 \
    18.210001 0 18.25 0 18.250001 -5e-11 18.26 -5e-11 \
    18.260001 0 18.3 0 18.300001 -5e-11 18.31 -5e-11 \
    18.310001 0 18.35 0 18.350001 -5e-11 18.36 -5e-11 \
    18.360001 0 18.4 0 18.400001 -5e-11 18.41 -5e-11 \
    18.410001 0 18.45 0 18.450001 -5e-11 18.46 -5e-11 \
    18.460001 0 18.5 0 18.500001 -5e-11 18.51 -5e-11 \
    18.510001 0 18.55 0 18.550001 -5e-11 18.56 -5e-11 \
    18.560001 0 18.6 0 18.600001 -5e-11 18.61 -5e-11 \
    18.610001 0 18.65 0 18.650001 -5e-11 18.66 -5e-11 \
    18.660001 0 18.7 0 18.700001 -5e-11 18.71 -5e-11 \
    18.710001 0 18.75 0 18.750001 -5e-11 18.76 -5e-11 \
    18.760001 0 18.8 0 18.800001 -5e-11 18.81 -5e-11 \
    18.810001 0 18.85 0 18.850001 -5e-11 18.86 -5e-11 \
    18.860001 0 18.9 0 18.900001 -5e-11 18.91 -5e-11 \
    18.910001 0 18.95 0 18.950001 -5e-11 18.96 -5e-11 \
    18.960001 0 19 0 19.000001 -5e-11 19.01 -5e-11 \
    19.010001 0 19.05 0 19.050001 -5e-11 19.06 -5e-11 \
    19.060001 0 19.1 0 19.100001 -5e-11 19.11 -5e-11 \
    19.110001 0 19.15 0 19.150001 -5e-11 19.16 -5e-11 \
    19.160001 0 19.2 0 19.200001 -5e-11 19.21 -5e-11 \
    19.210001 0 19.25 0 19.250001 -5e-11 19.26 -5e-11 \
    19.260001 0 19.3 0 19.300001 -5e-11 19.31 -5e-11 \
    19.310001 0 19.35 0 19.350001 -5e-11 19.36 -5e-11 \
    19.360001 0 19.4 0 19.400001 -5e-11 19.41 -5e-11 \
    19.410001 0 19.45 0 19.450001 -5e-11 19.46 -5e-11 \
    19.460001 0 19.5 0 19.500001 -5e-11 19.51 -5e-11 \
    19.510001 0 19.55 0 19.550001 -5e-11 19.56 -5e-11 \
    19.560001 0 19.6 0 19.600001 -5e-11 19.61 -5e-11 \
    19.610001 0 19.65 0 19.650001 -5e-11 19.66 -5e-11 \
    19.660001 0 19.7 0 19.700001 -5e-11 19.71 -5e-11 \
    19.710001 0 19.75 0 19.750001 -5e-11 19.76 -5e-11 \
    19.760001 0 19.8 0 19.800001 -5e-11 19.81 -5e-11 \
    19.810001 0 19.85 0 19.850001 -5e-11 19.86 -5e-11 \
    19.860001 0 19.9 0 19.900001 -5e-11 19.91 -5e-11 \
    19.910001 0 19.95 0 19.950001 -5e-11 19.96 -5e-11 \
    19.960001 0 20 0 20.000001 -5e-11 20.01 -5e-11 \
    20.010001 0 20.05 0 20.050001 -5e-11 20.06 -5e-11 \
    20.060001 0 20.1 0 20.100001 5e-11 20.11 5e-11 \
    20.110001 0 20.15 0 20.150001 5e-11 20.16 5e-11 \
    20.160001 0 20.2 0 20.200001 5e-11 20.21 5e-11 \
    20.210001 0 20.25 0 20.250001 5e-11 20.26 5e-11 \
    20.260001 0 20.3 0 20.300001 5e-11 20.31 5e-11 \
    20.310001 0 20.35 0 20.350001 5e-11 20.36 5e-11 \
    20.360001 0 20.4 0 20.400001 5e-11 20.41 5e-11 \
    20.410001 0 20.45 0 20.450001 5e-11 20.46 5e-11 \
    20.460001 0 20.5 0 20.500001 5e-11 20.51 5e-11 \
    20.510001 0 20.55 0 20.550001 5e-11 20.56 5e-11 \
    20.560001 0 20.6 0 20.600001 5e-11 20.61 5e-11 \
    20.610001 0 20.65 0 20.650001 5e-11 20.66 5e-11 \
    20.660001 0 20.7 0 20.700001 5e-11 20.71 5e-11 \
    20.710001 0 20.75 0 20.750001 5e-11 20.76 5e-11 \
    20.760001 0 20.8 0 20.800001 5e-11 20.81 5e-11 \
    20.810001 0 20.85 0 20.850001 5e-11 20.86 5e-11 \
    20.860001 0 20.9 0 20.900001 5e-11 20.91 5e-11 \
    20.910001 0 20.95 0 20.950001 5e-11 20.96 5e-11 \
    20.960001 0 21 0 21.000001 5e-11 21.01 5e-11 \
    21.010001 0 21.05 0 21.050001 5e-11 21.06 5e-11 \
    21.060001 0 21.1 0 21.100001 5e-11 21.11 5e-11 \
    21.110001 0 21.15 0 21.150001 5e-11 21.16 5e-11 \
    21.160001 0 21.2 0 21.200001 5e-11 21.21 5e-11 \
    21.210001 0 21.25 0 21.250001 5e-11 21.26 5e-11 \
    21.260001 0 21.3 0 21.300001 5e-11 21.31 5e-11 \
    21.310001 0 21.35 0 21.350001 5e-11 21.36 5e-11 \
    21.360001 0 21.4 0 21.400001 5e-11 21.41 5e-11 \
    21.410001 0 21.45 0 21.450001 5e-11 21.46 5e-11 \
    21.460001 0 21.5 0 21.500001 5e-11 21.51 5e-11 \
    21.510001 0 21.55 0 21.550001 5e-11 21.56 5e-11 \
    21.560001 0 21.6 0 21.600001 5e-11 21.61 5e-11 \
    21.610001 0 21.65 0 21.650001 5e-11 21.66 5e-11 \
    21.660001 0 21.7 0 21.700001 5e-11 21.71 5e-11 \
    21.710001 0 21.75 0 21.750001 5e-11 21.76 5e-11 \
    21.760001 0 21.8 0 21.800001 5e-11 21.81 5e-11 \
    21.810001 0 21.85 0 21.850001 5e-11 21.86 5e-11 \
    21.860001 0 21.9 0 21.900001 5e-11 21.91 5e-11 \
    21.910001 0 21.95 0 21.950001 5e-11 21.96 5e-11 \
    21.960001 0 22 0 22.000001 5e-11 22.01 5e-11 \
    22.010001 0 22.05 0 22.050001 5e-11 22.06 5e-11 \
    22.060001 0 22.1 0 22.100001 5e-11 22.11 5e-11 \
    22.110001 0 22.15 0 22.150001 5e-11 22.16 5e-11 \
    22.160001 0 22.2 0 22.200001 5e-11 22.21 5e-11 \
    22.210001 0 22.25 0 22.250001 5e-11 22.26 5e-11 \
    22.260001 0 22.3 0 22.300001 5e-11 22.31 5e-11 \
    22.310001 0 22.35 0 22.350001 5e-11 22.36 5e-11 \
    22.360001 0 22.4 0 22.400001 5e-11 22.41 5e-11 \
    22.410001 0 22.45 0 22.450001 5e-11 22.46 5e-11 \
    22.460001 0 22.5 0 22.500001 5e-11 22.51 5e-11 \
    22.510001 0 22.55 0 22.550001 5e-11 22.56 5e-11 \
    22.560001 0 22.6 0 22.600001 5e-11 22.61 5e-11 \
    22.610001 0 22.65 0 22.650001 5e-11 22.66 5e-11 \
    22.660001 0 22.7 0 22.700001 5e-11 22.71 5e-11 \
    22.710001 0 22.75 0 22.750001 5e-11 22.76 5e-11 \
    22.760001 0 22.8 0 22.800001 5e-11 22.81 5e-11 \
    22.810001 0 22.85 0 22.850001 5e-11 22.86 5e-11 \
    22.860001 0 22.9 0 22.900001 5e-11 22.91 5e-11 \
    22.910001 0 22.95 0 22.950001 5e-11 22.96 5e-11 \
    22.960001 0 23 0 23.000001 5e-11 23.01 5e-11 \
    23.010001 0 23.05 0 23.050001 5e-11 23.06 5e-11 \
    23.060001 0 23.1 0 23.100001 5e-11 23.11 5e-11 \
    23.110001 0 23.15 0 23.150001 5e-11 23.16 5e-11 \
    23.160001 0 23.2 0 23.200001 5e-11 23.21 5e-11 \
    23.210001 0 23.25 0 23.250001 5e-11 23.26 5e-11 \
    23.260001 0 23.3 0 23.300001 5e-11 23.31 5e-11 \
    23.310001 0 23.35 0 23.350001 5e-11 23.36 5e-11 \
    23.360001 0 23.4 0 23.400001 5e-11 23.41 5e-11 \
    23.410001 0 23.45 0 23.450001 5e-11 23.46 5e-11 \
    23.460001 0 23.5 0 23.500001 5e-11 23.51 5e-11 \
    23.510001 0 23.55 0 23.550001 5e-11 23.56 5e-11 \
    23.560001 0 23.6 0 23.600001 5e-11 23.61 5e-11 \
    23.610001 0 23.65 0 23.650001 5e-11 23.66 5e-11 \
    23.660001 0 23.7 0 23.700001 5e-11 23.71 5e-11 \
    23.710001 0 23.75 0 23.750001 5e-11 23.76 5e-11 \
    23.760001 0 23.8 0 23.800001 5e-11 23.81 5e-11 \
    23.810001 0 23.85 0 23.850001 5e-11 23.86 5e-11 \
    23.860001 0 23.9 0 23.900001 5e-11 23.91 5e-11 \
    23.910001 0 23.95 0 23.950001 5e-11 23.96 5e-11 \
    23.960001 0 24 0 24.000001 5e-11 24.01 5e-11 \
    24.010001 0 24.05 0 24.050001 5e-11 24.06 5e-11 \
    24.060001 0 24.1 0 24.100001 5e-11 24.11 5e-11 \
    24.110001 0 24.15 0 24.150001 5e-11 24.16 5e-11 \
    24.160001 0 24.2 0 24.200001 5e-11 24.21 5e-11 \
    24.210001 0 24.25 0 24.250001 5e-11 24.26 5e-11 \
    24.260001 0 24.3 0 24.300001 5e-11 24.31 5e-11 \
    24.310001 0 24.35 0 24.350001 5e-11 24.36 5e-11 \
    24.360001 0 24.4 0 24.400001 5e-11 24.41 5e-11 \
    24.410001 0 24.45 0 24.450001 5e-11 24.46 5e-11 \
    24.460001 0 24.5 0 24.500001 5e-11 24.51 5e-11 \
    24.510001 0 24.55 0 24.550001 5e-11 24.56 5e-11 \
    24.560001 0 24.6 0 24.600001 5e-11 24.61 5e-11 \
    24.610001 0 24.65 0 24.650001 5e-11 24.66 5e-11 \
    24.660001 0 24.7 0 24.700001 5e-11 24.71 5e-11 \
    24.710001 0 24.75 0 24.750001 5e-11 24.76 5e-11 \
    24.760001 0 24.8 0 24.800001 5e-11 24.81 5e-11 \
    24.810001 0 24.85 0 24.850001 5e-11 24.86 5e-11 \
    24.860001 0 24.9 0 24.900001 5e-11 24.91 5e-11 \
    24.910001 0 24.95 0 24.950001 5e-11 24.96 5e-11 \
    24.960001 0 25 0 25.000001 5e-11 25.01 5e-11 \
    25.010001 0 25.05 0 25.050001 5e-11 25.06 5e-11 \
    25.060001 0 25.1 0 25.100001 5e-11 25.11 5e-11 \
    25.110001 0 25.15 0 25.150001 5e-11 25.16 5e-11 \
    25.160001 0 25.2 0 25.200001 5e-11 25.21 5e-11 \
    25.210001 0 25.25 0 25.250001 5e-11 25.26 5e-11 \
    25.260001 0 25.3 0 25.300001 5e-11 25.31 5e-11 \
    25.310001 0 25.35 0 25.350001 5e-11 25.36 5e-11 \
    25.360001 0 25.4 0 25.400001 5e-11 25.41 5e-11 \
    25.410001 0 25.45 0 25.450001 5e-11 25.46 5e-11 \
    25.460001 0 25.5 0 25.500001 5e-11 25.51 5e-11 \
    25.510001 0 25.55 0 25.550001 5e-11 25.56 5e-11 \
    25.560001 0 25.6 0 25.600001 5e-11 25.61 5e-11 \
    25.610001 0 25.65 0 25.650001 5e-11 25.66 5e-11 \
    25.660001 0 25.7 0 25.700001 5e-11 25.71 5e-11 \
    25.710001 0 25.75 0 25.750001 5e-11 25.76 5e-11 \
    25.760001 0 25.8 0 25.800001 5e-11 25.81 5e-11 \
    25.810001 0 25.85 0 25.850001 5e-11 25.86 5e-11 \
    25.860001 0 25.9 0 25.900001 5e-11 25.91 5e-11 \
    25.910001 0 25.95 0 25.950001 5e-11 25.96 5e-11 \
    25.960001 0 26 0 26.000001 5e-11 26.01 5e-11 \
    26.010001 0 26.05 0 26.050001 5e-11 26.06 5e-11 \
    26.060001 0 26.1 0 26.100001 5e-11 26.11 5e-11 \
    26.110001 0 26.15 0 26.150001 5e-11 26.16 5e-11 \
    26.160001 0 26.2 0 26.200001 5e-11 26.21 5e-11 \
    26.210001 0 26.25 0 26.250001 5e-11 26.26 5e-11 \
    26.260001 0 26.3 0 26.300001 5e-11 26.31 5e-11 \
    26.310001 0 26.35 0 26.350001 5e-11 26.36 5e-11 \
    26.360001 0 26.4 0 26.400001 5e-11 26.41 5e-11 \
    26.410001 0 26.45 0 26.450001 5e-11 26.46 5e-11 \
    26.460001 0 26.5 0 26.500001 5e-11 26.51 5e-11 \
    26.510001 0 26.55 0 26.550001 5e-11 26.56 5e-11 \
    26.560001 0 26.6 0 26.600001 5e-11 26.61 5e-11 \
    26.610001 0 26.65 0 26.650001 5e-11 26.66 5e-11 \
    26.660001 0 26.7 0 26.700001 5e-11 26.71 5e-11 \
    26.710001 0 26.75 0 26.750001 5e-11 26.76 5e-11 \
    26.760001 0 26.8 0 26.800001 5e-11 26.81 5e-11 \
    26.810001 0 26.85 0 26.850001 5e-11 26.86 5e-11 \
    26.860001 0 26.9 0 26.900001 5e-11 26.91 5e-11 \
    26.910001 0 26.95 0 26.950001 5e-11 26.96 5e-11 \
    26.960001 0 27 0 27.000001 5e-11 27.01 5e-11 \
    27.010001 0 27.05 0 27.050001 5e-11 27.06 5e-11 \
    27.060001 0 27.1 0 27.100001 5e-11 27.11 5e-11 \
    27.110001 0 27.15 0 27.150001 5e-11 27.16 5e-11 \
    27.160001 0 27.2 0 27.200001 5e-11 27.21 5e-11 \
    27.210001 0 27.25 0 27.250001 5e-11 27.26 5e-11 \
    27.260001 0 27.3 0 27.300001 5e-11 27.31 5e-11 \
    27.310001 0 27.35 0 27.350001 5e-11 27.36 5e-11 \
    27.360001 0 27.4 0 27.400001 5e-11 27.41 5e-11 \
    27.410001 0 27.45 0 27.450001 5e-11 27.46 5e-11 \
    27.460001 0 27.5 0 27.500001 5e-11 27.51 5e-11 \
    27.510001 0 27.55 0 27.550001 5e-11 27.56 5e-11 \
    27.560001 0 27.6 0 27.600001 5e-11 27.61 5e-11 \
    27.610001 0 27.65 0 27.650001 5e-11 27.66 5e-11 \
    27.660001 0 27.7 0 27.700001 5e-11 27.71 5e-11 \
    27.710001 0 27.75 0 27.750001 5e-11 27.76 5e-11 \
    27.760001 0 27.8 0 27.800001 5e-11 27.81 5e-11 \
    27.810001 0 27.85 0 27.850001 5e-11 27.86 5e-11 \
    27.860001 0 27.9 0 27.900001 5e-11 27.91 5e-11 \
    27.910001 0 27.95 0 27.950001 5e-11 27.96 5e-11 \
    27.960001 0 28 0 28.000001 5e-11 28.01 5e-11 \
    28.010001 0 28.05 0 28.050001 5e-11 28.06 5e-11 \
    28.060001 0 28.1 0 28.100001 5e-11 28.11 5e-11 \
    28.110001 0 28.15 0 28.150001 5e-11 28.16 5e-11 \
    28.160001 0 28.2 0 28.200001 5e-11 28.21 5e-11 \
    28.210001 0 28.25 0 28.250001 5e-11 28.26 5e-11 \
    28.260001 0 28.3 0 28.300001 5e-11 28.31 5e-11 \
    28.310001 0 28.35 0 28.350001 5e-11 28.36 5e-11 \
    28.360001 0 28.4 0 28.400001 5e-11 28.41 5e-11 \
    28.410001 0 28.45 0 28.450001 5e-11 28.46 5e-11 \
    28.460001 0 28.5 0 28.500001 5e-11 28.51 5e-11 \
    28.510001 0 28.55 0 28.550001 5e-11 28.56 5e-11 \
    28.560001 0 28.6 0 28.600001 5e-11 28.61 5e-11 \
    28.610001 0 28.65 0 28.650001 5e-11 28.66 5e-11 \
    28.660001 0 28.7 0 28.700001 5e-11 28.71 5e-11 \
    28.710001 0 28.75 0 28.750001 5e-11 28.76 5e-11 \
    28.760001 0 28.8 0 28.800001 5e-11 28.81 5e-11 \
    28.810001 0 28.85 0 28.850001 5e-11 28.86 5e-11 \
    28.860001 0 28.9 0 28.900001 5e-11 28.91 5e-11 \
    28.910001 0 28.95 0 28.950001 5e-11 28.96 5e-11 \
    28.960001 0 29 0 29.000001 5e-11 29.01 5e-11 \
    29.010001 0 29.05 0 29.050001 5e-11 29.06 5e-11 \
    29.060001 0 29.1 0 29.100001 5e-11 29.11 5e-11 \
    29.110001 0 29.15 0 29.150001 5e-11 29.16 5e-11 \
    29.160001 0 29.2 0 29.200001 5e-11 29.21 5e-11 \
    29.210001 0 29.25 0 29.250001 5e-11 29.26 5e-11 \
    29.260001 0 29.3 0 29.300001 5e-11 29.31 5e-11 \
    29.310001 0 29.35 0 29.350001 5e-11 29.36 5e-11 \
    29.360001 0 29.4 0 29.400001 5e-11 29.41 5e-11 \
    29.410001 0 29.45 0 29.450001 5e-11 29.46 5e-11 \
    29.460001 0 29.5 0 29.500001 5e-11 29.51 5e-11 \
    29.510001 0 29.55 0 29.550001 5e-11 29.56 5e-11 \
    29.560001 0 29.6 0 29.600001 5e-11 29.61 5e-11 \
    29.610001 0 29.65 0 29.650001 5e-11 29.66 5e-11 \
    29.660001 0 29.7 0 29.700001 5e-11 29.71 5e-11 \
    29.710001 0 29.75 0 29.750001 5e-11 29.76 5e-11 \
    29.760001 0 29.8 0 29.800001 5e-11 29.81 5e-11 \
    29.810001 0 29.85 0 29.850001 5e-11 29.86 5e-11 \
    29.860001 0 29.9 0 29.900001 5e-11 29.91 5e-11 \
    29.910001 0 29.95 0 29.950001 5e-11 29.96 5e-11 \
    29.960001 0 30 0 30.000001 5e-11 30.01 5e-11 \
    30.010001 0 30.05 0 30.050001 5e-11 30.06 5e-11 \
    30.060001 0 30.1 0 30.100001 5e-11 30.11 5e-11 \
    30.110001 0 30.15 0 30.150001 5e-11 30.16 5e-11 \
    30.160001 0 30.2 0 30.200001 5e-11 30.21 5e-11 \
    30.210001 0 30.25 0 30.250001 5e-11 30.26 5e-11 \
    30.260001 0 30.3 0 30.300001 5e-11 30.31 5e-11 \
    30.310001 0 30.35 0 30.350001 5e-11 30.36 5e-11 \
    30.360001 0 30.4 0 30.400001 5e-11 30.41 5e-11 \
    30.410001 0 30.45 0 30.450001 5e-11 30.46 5e-11 \
    30.460001 0 30.5 0 30.500001 5e-11 30.51 5e-11 \
    30.510001 0 30.55 0 30.550001 5e-11 30.56 5e-11 \
    30.560001 0 30.6 0 30.600001 5e-11 30.61 5e-11 \
    30.610001 0 30.65 0 30.650001 5e-11 30.66 5e-11 \
    30.660001 0 30.7 0 30.700001 5e-11 30.71 5e-11 \
    30.710001 0 30.75 0 30.750001 5e-11 30.76 5e-11 \
    30.760001 0 30.8 0 30.800001 5e-11 30.81 5e-11 \
    30.810001 0 30.85 0 30.850001 5e-11 30.86 5e-11 \
    30.860001 0 30.9 0 30.900001 5e-11 30.91 5e-11 \
    30.910001 0 30.95 0 30.950001 5e-11 30.96 5e-11 \
    30.960001 0 31 0 31.000001 5e-11 31.01 5e-11 \
    31.010001 0 31.05 0 31.050001 5e-11 31.06 5e-11 \
    31.060001 0 31.1 0 31.100001 5e-11 31.11 5e-11 \
    31.110001 0 31.15 0 31.150001 5e-11 31.16 5e-11 \
    31.160001 0 31.2 0 31.200001 5e-11 31.21 5e-11 \
    31.210001 0 31.25 0 31.250001 5e-11 31.26 5e-11 \
    31.260001 0 31.3 0 31.300001 5e-11 31.31 5e-11 \
    31.310001 0 31.35 0 31.350001 5e-11 31.36 5e-11 \
    31.360001 0 31.4 0 31.400001 5e-11 31.41 5e-11 \
    31.410001 0 31.45 0 31.450001 5e-11 31.46 5e-11 \
    31.460001 0 31.5 0 31.500001 5e-11 31.51 5e-11 \
    31.510001 0 31.55 0 31.550001 5e-11 31.56 5e-11 \
    31.560001 0 31.6 0 31.600001 5e-11 31.61 5e-11 \
    31.610001 0 31.65 0 31.650001 5e-11 31.66 5e-11 \
    31.660001 0 31.7 0 31.700001 5e-11 31.71 5e-11 \
    31.710001 0 31.75 0 31.750001 5e-11 31.76 5e-11 \
    31.760001 0 31.8 0 31.800001 5e-11 31.81 5e-11 \
    31.810001 0 31.85 0 31.850001 5e-11 31.86 5e-11 \
    31.860001 0 31.9 0 31.900001 5e-11 31.91 5e-11 \
    31.910001 0 31.95 0 31.950001 5e-11 31.96 5e-11 \
    31.960001 0 32 0 32.000001 5e-11 32.01 5e-11 \
    32.010001 0 32.05 0 32.050001 5e-11 32.06 5e-11 \
    32.060001 0 32.1 0 32.100001 5e-11 32.11 5e-11 \
    32.110001 0 32.15 0 32.150001 5e-11 32.16 5e-11 \
    32.160001 0 32.2 0 32.200001 5e-11 32.21 5e-11 \
    32.210001 0 32.25 0 32.250001 5e-11 32.26 5e-11 \
    32.260001 0 32.3 0 32.300001 5e-11 32.31 5e-11 \
    32.310001 0 32.35 0 32.350001 5e-11 32.36 5e-11 \
    32.360001 0 32.4 0 32.400001 5e-11 32.41 5e-11 \
    32.410001 0 32.45 0 32.450001 5e-11 32.46 5e-11 \
    32.460001 0 32.5 0 32.500001 5e-11 32.51 5e-11 \
    32.510001 0 32.55 0 32.550001 5e-11 32.56 5e-11 \
    32.560001 0 32.6 0 32.600001 5e-11 32.61 5e-11 \
    32.610001 0 32.65 0 32.650001 5e-11 32.66 5e-11 \
    32.660001 0 32.7 0 32.700001 5e-11 32.71 5e-11 \
    32.710001 0 32.75 0 32.750001 5e-11 32.76 5e-11 \
    32.760001 0 32.8 0 32.800001 5e-11 32.81 5e-11 \
    32.810001 0 32.85 0 32.850001 5e-11 32.86 5e-11 \
    32.860001 0 32.9 0 32.900001 5e-11 32.91 5e-11 \
    32.910001 0 32.95 0 32.950001 5e-11 32.96 5e-11 \
    32.960001 0 33 0 33.000001 5e-11 33.01 5e-11 \
    33.010001 0 33.05 0 33.050001 5e-11 33.06 5e-11 \
    33.060001 0 33.1 0 33.100001 5e-11 33.11 5e-11 \
    33.110001 0 33.15 0 33.150001 5e-11 33.16 5e-11 \
    33.160001 0 33.2 0 33.200001 5e-11 33.21 5e-11 \
    33.210001 0 33.25 0 33.250001 5e-11 33.26 5e-11 \
    33.260001 0 33.3 0 33.300001 5e-11 33.31 5e-11 \
    33.310001 0 33.35 0 33.350001 5e-11 33.36 5e-11 \
    33.360001 0 33.4 0 33.400001 5e-11 33.41 5e-11 \
    33.410001 0 33.45 0 33.450001 5e-11 33.46 5e-11 \
    33.460001 0 33.5 0 33.500001 5e-11 33.51 5e-11 \
    33.510001 0 33.55 0 33.550001 5e-11 33.56 5e-11 \
    33.560001 0 33.6 0 33.600001 5e-11 33.61 5e-11 \
    33.610001 0 33.65 0 33.650001 5e-11 33.66 5e-11 \
    33.660001 0 33.7 0 33.700001 5e-11 33.71 5e-11 \
    33.710001 0 33.75 0 33.750001 5e-11 33.76 5e-11 \
    33.760001 0 33.8 0 33.800001 5e-11 33.81 5e-11 \
    33.810001 0 33.85 0 33.850001 5e-11 33.86 5e-11 \
    33.860001 0 33.9 0 33.900001 5e-11 33.91 5e-11 \
    33.910001 0 33.95 0 33.950001 5e-11 33.96 5e-11 \
    33.960001 0 34 0 34.000001 5e-11 34.01 5e-11 \
    34.010001 0 34.05 0 34.050001 5e-11 34.06 5e-11 \
    34.060001 0 34.1 0 34.100001 5e-11 34.11 5e-11 \
    34.110001 0 34.15 0 34.150001 5e-11 34.16 5e-11 \
    34.160001 0 34.2 0 34.200001 5e-11 34.21 5e-11 \
    34.210001 0 34.25 0 34.250001 5e-11 34.26 5e-11 \
    34.260001 0 34.3 0 34.300001 5e-11 34.31 5e-11 \
    34.310001 0 34.35 0 34.350001 5e-11 34.36 5e-11 \
    34.360001 0 34.4 0 34.400001 5e-11 34.41 5e-11 \
    34.410001 0 34.45 0 34.450001 5e-11 34.46 5e-11 \
    34.460001 0 34.5 0 34.500001 5e-11 34.51 5e-11 \
    34.510001 0 34.55 0 34.550001 5e-11 34.56 5e-11 \
    34.560001 0 34.6 0 34.600001 5e-11 34.61 5e-11 \
    34.610001 0 34.65 0 34.650001 5e-11 34.66 5e-11 \
    34.660001 0 34.7 0 34.700001 5e-11 34.71 5e-11 \
    34.710001 0 34.75 0 34.750001 5e-11 34.76 5e-11 \
    34.760001 0 34.8 0 34.800001 5e-11 34.81 5e-11 \
    34.810001 0 34.85 0 34.850001 5e-11 34.86 5e-11 \
    34.860001 0 34.9 0 34.900001 5e-11 34.91 5e-11 \
    34.910001 0 34.95 0 34.950001 5e-11 34.96 5e-11 \
    34.960001 0 35 0 35.000001 5e-11 35.01 5e-11 \
    35.010001 0 35.05 0 35.050001 5e-11 35.06 5e-11 \
    35.060001 0 35.1 0 35.100001 5e-11 35.11 5e-11 \
    35.110001 0 35.15 0 35.150001 5e-11 35.16 5e-11 \
    35.160001 0 35.2 0 35.200001 5e-11 35.21 5e-11 \
    35.210001 0 35.25 0 35.250001 5e-11 35.26 5e-11 \
    35.260001 0 35.3 0 35.300001 5e-11 35.31 5e-11 \
    35.310001 0 35.35 0 35.350001 5e-11 35.36 5e-11 \
    35.360001 0 35.4 0 35.400001 5e-11 35.41 5e-11 \
    35.410001 0 35.45 0 35.450001 5e-11 35.46 5e-11 \
    35.460001 0 35.5 0 35.500001 5e-11 35.51 5e-11 \
    35.510001 0 35.55 0 35.550001 5e-11 35.56 5e-11 \
    35.560001 0 35.6 0 35.600001 5e-11 35.61 5e-11 \
    35.610001 0 35.65 0 35.650001 5e-11 35.66 5e-11 \
    35.660001 0 35.7 0 35.700001 5e-11 35.71 5e-11 \
    35.710001 0 35.75 0 35.750001 5e-11 35.76 5e-11 \
    35.760001 0 35.8 0 35.800001 5e-11 35.81 5e-11 \
    35.810001 0 35.85 0 35.850001 5e-11 35.86 5e-11 \
    35.860001 0 35.9 0 35.900001 5e-11 35.91 5e-11 \
    35.910001 0 35.95 0 35.950001 5e-11 35.96 5e-11 \
    35.960001 0 36 0 36.000001 5e-11 36.01 5e-11 \
    36.010001 0 36.05 0 36.050001 5e-11 36.06 5e-11 \
    36.060001 0 36.1 0 36.100001 5e-11 36.11 5e-11 \
    36.110001 0 36.15 0 36.150001 5e-11 36.16 5e-11 \
    36.160001 0 36.2 0 36.200001 5e-11 36.21 5e-11 \
    36.210001 0 36.25 0 36.250001 5e-11 36.26 5e-11 \
    36.260001 0 36.3 0 36.300001 5e-11 36.31 5e-11 \
    36.310001 0 36.35 0 36.350001 5e-11 36.36 5e-11 \
    36.360001 0 36.4 0 36.400001 5e-11 36.41 5e-11 \
    36.410001 0 36.45 0 36.450001 5e-11 36.46 5e-11 \
    36.460001 0 36.5 0 36.500001 5e-11 36.51 5e-11 \
    36.510001 0 36.55 0 36.550001 5e-11 36.56 5e-11 \
    36.560001 0 36.6 0 36.600001 5e-11 36.61 5e-11 \
    36.610001 0 36.65 0 36.650001 5e-11 36.66 5e-11 \
    36.660001 0 36.7 0 36.700001 5e-11 36.71 5e-11 \
    36.710001 0 36.75 0 36.750001 5e-11 36.76 5e-11 \
    36.760001 0 36.8 0 36.800001 5e-11 36.81 5e-11 \
    36.810001 0 36.85 0 36.850001 5e-11 36.86 5e-11 \
    36.860001 0 36.9 0 36.900001 5e-11 36.91 5e-11 \
    36.910001 0 36.95 0 36.950001 5e-11 36.96 5e-11 \
    36.960001 0 37 0 37.000001 5e-11 37.01 5e-11 \
    37.010001 0 37.05 0 37.050001 5e-11 37.06 5e-11 \
    37.060001 0 37.1 0 37.100001 5e-11 37.11 5e-11 \
    37.110001 0 37.15 0 37.150001 5e-11 37.16 5e-11 \
    37.160001 0 37.2 0 37.200001 5e-11 37.21 5e-11 \
    37.210001 0 37.25 0 37.250001 5e-11 37.26 5e-11 \
    37.260001 0 37.3 0 37.300001 5e-11 37.31 5e-11 \
    37.310001 0 37.35 0 37.350001 5e-11 37.36 5e-11 \
    37.360001 0 37.4 0 37.400001 5e-11 37.41 5e-11 \
    37.410001 0 37.45 0 37.450001 5e-11 37.46 5e-11 \
    37.460001 0 37.5 0 37.500001 5e-11 37.51 5e-11 \
    37.510001 0 37.55 0 37.550001 5e-11 37.56 5e-11 \
    37.560001 0 37.6 0 37.600001 5e-11 37.61 5e-11 \
    37.610001 0 37.65 0 37.650001 5e-11 37.66 5e-11 \
    37.660001 0 37.7 0 37.700001 5e-11 37.71 5e-11 \
    37.710001 0 37.75 0 37.750001 5e-11 37.76 5e-11 \
    37.760001 0 37.8 0 37.800001 5e-11 37.81 5e-11 \
    37.810001 0 37.85 0 37.850001 5e-11 37.86 5e-11 \
    37.860001 0 37.9 0 37.900001 5e-11 37.91 5e-11 \
    37.910001 0 37.95 0 37.950001 5e-11 37.96 5e-11 \
    37.960001 0 38 0 38.000001 5e-11 38.01 5e-11 \
    38.010001 0 38.05 0 38.050001 5e-11 38.06 5e-11 \
    38.060001 0 38.1 0 38.100001 5e-11 38.11 5e-11 \
    38.110001 0 38.15 0 38.150001 5e-11 38.16 5e-11 \
    38.160001 0 38.2 0 38.200001 5e-11 38.21 5e-11 \
    38.210001 0 38.25 0 38.250001 5e-11 38.26 5e-11 \
    38.260001 0 38.3 0 38.300001 5e-11 38.31 5e-11 \
    38.310001 0 38.35 0 38.350001 5e-11 38.36 5e-11 \
    38.360001 0 38.4 0 38.400001 5e-11 38.41 5e-11 \
    38.410001 0 38.45 0 38.450001 5e-11 38.46 5e-11 \
    38.460001 0 38.5 0 38.500001 5e-11 38.51 5e-11 \
    38.510001 0 38.55 0 38.550001 5e-11 38.56 5e-11 \
    38.560001 0 38.6 0 38.600001 5e-11 38.61 5e-11 \
    38.610001 0 38.65 0 38.650001 5e-11 38.66 5e-11 \
    38.660001 0 38.7 0 38.700001 5e-11 38.71 5e-11 \
    38.710001 0 38.75 0 38.750001 5e-11 38.76 5e-11 \
    38.760001 0 38.8 0 38.800001 5e-11 38.81 5e-11 \
    38.810001 0 38.85 0 38.850001 5e-11 38.86 5e-11 \
    38.860001 0 38.9 0 38.900001 5e-11 38.91 5e-11 \
    38.910001 0 38.95 0 38.950001 5e-11 38.96 5e-11 \
    38.960001 0 39 0 39.000001 5e-11 39.01 5e-11 \
    39.010001 0 39.05 0 39.050001 5e-11 39.06 5e-11 \
    39.060001 0 39.1 0 39.100001 5e-11 39.11 5e-11 \
    39.110001 0 39.15 0 39.150001 5e-11 39.16 5e-11 \
    39.160001 0 39.2 0 39.200001 5e-11 39.21 5e-11 \
    39.210001 0 39.25 0 39.250001 5e-11 39.26 5e-11 \
    39.260001 0 39.3 0 39.300001 5e-11 39.31 5e-11 \
    39.310001 0 39.35 0 39.350001 5e-11 39.36 5e-11 \
    39.360001 0 39.4 0 39.400001 5e-11 39.41 5e-11 \
    39.410001 0 39.45 0 39.450001 5e-11 39.46 5e-11 \
    39.460001 0 39.5 0 39.500001 5e-11 39.51 5e-11 \
    39.510001 0 39.55 0 39.550001 5e-11 39.56 5e-11 \
    39.560001 0 39.6 0 39.600001 5e-11 39.61 5e-11 \
    39.610001 0 39.65 0 39.650001 5e-11 39.66 5e-11 \
    39.660001 0 39.7 0 39.700001 5e-11 39.71 5e-11 \
    39.710001 0 39.75 0 39.750001 5e-11 39.76 5e-11 \
    39.760001 0 39.8 0 39.800001 5e-11 39.81 5e-11 \
    39.810001 0 39.85 0 39.850001 5e-11 39.86 5e-11 \
    39.860001 0 39.9 0 39.900001 5e-11 39.91 5e-11 \
    39.910001 0 39.95 0 39.950001 5e-11 39.96 5e-11 \
    39.960001 0 40 0 40.000001 5e-11 40.01 5e-11 \
    40.010001 0 40.05 0 40.050001 5e-11 40.06 5e-11 \
    40.060001 0 40.1 0 40.100001 5e-11 40.11 5e-11 \
    40.110001 0 40.15 0 40.150001 5e-11 40.16 5e-11 \
    40.160001 0 40.2 0 40.200001 5e-11 40.21 5e-11 \
    40.210001 0 40.25 0 40.250001 5e-11 40.26 5e-11 \
    40.260001 0 40.3 0 40.300001 5e-11 40.31 5e-11 \
    40.310001 0 40.35 0 40.350001 5e-11 40.36 5e-11 \
    40.360001 0 40.4 0 40.400001 5e-11 40.41 5e-11 \
    40.410001 0 40.45 0 40.450001 5e-11 40.46 5e-11 \
    40.460001 0 40.5 0 40.500001 5e-11 40.51 5e-11 \
    40.510001 0 40.55 0 40.550001 5e-11 40.56 5e-11 \
    40.560001 0 40.6 0 40.600001 5e-11 40.61 5e-11 \
    40.610001 0 40.65 0 40.650001 5e-11 40.66 5e-11 \
    40.660001 0 40.7 0 40.700001 5e-11 40.71 5e-11 \
    40.710001 0 40.75 0 40.750001 5e-11 40.76 5e-11 \
    40.760001 0 40.8 0 40.800001 5e-11 40.81 5e-11 \
    40.810001 0 40.85 0 40.850001 5e-11 40.86 5e-11 \
    40.860001 0 40.9 0 40.900001 5e-11 40.91 5e-11 \
    40.910001 0 40.95 0 40.950001 5e-11 40.96 5e-11 \
    40.960001 0 41 0 41.000001 5e-11 41.01 5e-11 \
    41.010001 0 41.05 0 41.050001 5e-11 41.06 5e-11 \
    41.060001 0 41.1 0 41.100001 5e-11 41.11 5e-11 \
    41.110001 0 41.15 0 41.150001 5e-11 41.16 5e-11 \
    41.160001 0 41.2 0 41.200001 5e-11 41.21 5e-11 \
    41.210001 0 41.25 0 41.250001 5e-11 41.26 5e-11 \
    41.260001 0 41.3 0 41.300001 5e-11 41.31 5e-11 \
    41.310001 0 41.35 0 41.350001 5e-11 41.36 5e-11 \
    41.360001 0 41.4 0 41.400001 5e-11 41.41 5e-11 \
    41.410001 0 41.45 0 41.450001 5e-11 41.46 5e-11 \
    41.460001 0 41.5 0 41.500001 5e-11 41.51 5e-11 \
    41.510001 0 41.55 0 41.550001 5e-11 41.56 5e-11 \
    41.560001 0 41.6 0 41.600001 5e-11 41.61 5e-11 \
    41.610001 0 41.65 0 41.650001 5e-11 41.66 5e-11 \
    41.660001 0 41.7 0 41.700001 5e-11 41.71 5e-11 \
    41.710001 0 41.75 0 41.750001 5e-11 41.76 5e-11 \
    41.760001 0 41.8 0 41.800001 5e-11 41.81 5e-11 \
    41.810001 0 41.85 0 41.850001 5e-11 41.86 5e-11 \
    41.860001 0 41.9 0 41.900001 5e-11 41.91 5e-11 \
    41.910001 0 41.95 0 41.950001 5e-11 41.96 5e-11 \
    41.960001 0 42 0 42.000001 5e-11 42.01 5e-11 \
    42.010001 0 42.05 0 42.050001 5e-11 42.06 5e-11 \
    42.060001 0 42.1 0 42.100001 5e-11 42.11 5e-11 \
    42.110001 0 42.15 0 42.150001 5e-11 42.16 5e-11 \
    42.160001 0 42.2 0 42.200001 5e-11 42.21 5e-11 \
    42.210001 0 42.25 0 42.250001 5e-11 42.26 5e-11 \
    42.260001 0 42.3 0 42.300001 5e-11 42.31 5e-11 \
    42.310001 0 42.35 0 42.350001 5e-11 42.36 5e-11 \
    42.360001 0 42.4 0 42.400001 5e-11 42.41 5e-11 \
    42.410001 0 42.45 0 42.450001 5e-11 42.46 5e-11 \
    42.460001 0 42.5 0 42.500001 5e-11 42.51 5e-11 \
    42.510001 0 42.55 0 42.550001 5e-11 42.56 5e-11 \
    42.560001 0 42.6 0 42.600001 5e-11 42.61 5e-11 \
    42.610001 0 42.65 0 42.650001 5e-11 42.66 5e-11 \
    42.660001 0 42.7 0 42.700001 5e-11 42.71 5e-11 \
    42.710001 0 42.75 0 42.750001 5e-11 42.76 5e-11 \
    42.760001 0 42.8 0 42.800001 5e-11 42.81 5e-11 \
    42.810001 0 42.85 0 42.850001 5e-11 42.86 5e-11 \
    42.860001 0 42.9 0 42.900001 5e-11 42.91 5e-11 \
    42.910001 0 42.95 0 42.950001 5e-11 42.96 5e-11 \
    42.960001 0 43 0 43.000001 5e-11 43.01 5e-11 \
    43.010001 0 43.05 0 43.050001 5e-11 43.06 5e-11 \
    43.060001 0 43.1 0 43.100001 5e-11 43.11 5e-11 \
    43.110001 0 43.15 0 43.150001 5e-11 43.16 5e-11 \
    43.160001 0 43.2 0 43.200001 5e-11 43.21 5e-11 \
    43.210001 0 43.25 0 43.250001 5e-11 43.26 5e-11 \
    43.260001 0 43.3 0 43.300001 5e-11 43.31 5e-11 \
    43.310001 0 43.35 0 43.350001 5e-11 43.36 5e-11 \
    43.360001 0 43.4 0 43.400001 5e-11 43.41 5e-11 \
    43.410001 0 43.45 0 43.450001 5e-11 43.46 5e-11 \
    43.460001 0 43.5 0 43.500001 5e-11 43.51 5e-11 \
    43.510001 0 43.55 0 43.550001 5e-11 43.56 5e-11 \
    43.560001 0 43.6 0 43.600001 5e-11 43.61 5e-11 \
    43.610001 0 43.65 0 43.650001 5e-11 43.66 5e-11 \
    43.660001 0 43.7 0 43.700001 5e-11 43.71 5e-11 \
    43.710001 0 43.75 0 43.750001 5e-11 43.76 5e-11 \
    43.760001 0 43.8 0 43.800001 5e-11 43.81 5e-11 \
    43.810001 0 43.85 0 43.850001 5e-11 43.86 5e-11 \
    43.860001 0 43.9 0 43.900001 5e-11 43.91 5e-11 \
    43.910001 0 43.95 0 43.950001 5e-11 43.96 5e-11 \
    43.960001 0 44 0 44.000001 5e-11 44.01 5e-11 \
    44.010001 0 44.05 0 44.050001 5e-11 44.06 5e-11 \
    44.060001 0 44.1 0 44.100001 5e-11 44.11 5e-11 \
    44.110001 0 44.15 0 44.150001 5e-11 44.16 5e-11 \
    44.160001 0 44.2 0 44.200001 5e-11 44.21 5e-11 \
    44.210001 0 44.25 0 44.250001 5e-11 44.26 5e-11 \
    44.260001 0 44.3 0 44.300001 5e-11 44.31 5e-11 \
    44.310001 0 44.35 0 44.350001 5e-11 44.36 5e-11 \
    44.360001 0 44.4 0 44.400001 5e-11 44.41 5e-11 \
    44.410001 0 44.45 0 44.450001 5e-11 44.46 5e-11 \
    44.460001 0 44.5 0 44.500001 5e-11 44.51 5e-11 \
    44.510001 0 44.55 0 44.550001 5e-11 44.56 5e-11 \
    44.560001 0 44.6 0 44.600001 5e-11 44.61 5e-11 \
    44.610001 0 44.65 0 44.650001 5e-11 44.66 5e-11 \
    44.660001 0 44.7 0 44.700001 5e-11 44.71 5e-11 \
    44.710001 0 44.75 0 44.750001 5e-11 44.76 5e-11 \
    44.760001 0 44.8 0 44.800001 5e-11 44.81 5e-11 \
    44.810001 0 44.85 0 44.850001 5e-11 44.86 5e-11 \
    44.860001 0 44.9 0 44.900001 5e-11 44.91 5e-11 \
    44.910001 0 44.95 0 44.950001 5e-11 44.96 5e-11 \
    44.960001 0 45 0 45.000001 5e-11 45.01 5e-11 \
    45.010001 0 45.05 0 45.050001 5e-11 45.06 5e-11 \
    45.060001 0 45.1 0 45.100001 5e-11 45.11 5e-11 \
    45.110001 0 45.15 0 45.150001 5e-11 45.16 5e-11 \
    45.160001 0 45.2 0 45.200001 5e-11 45.21 5e-11 \
    45.210001 0 45.25 0 45.250001 5e-11 45.26 5e-11 \
    45.260001 0 45.3 0 45.300001 5e-11 45.31 5e-11 \
    45.310001 0 45.35 0 45.350001 5e-11 45.36 5e-11 \
    45.360001 0 45.4 0 45.400001 5e-11 45.41 5e-11 \
    45.410001 0 45.45 0 45.450001 5e-11 45.46 5e-11 \
    45.460001 0 45.5 0 45.500001 5e-11 45.51 5e-11 \
    45.510001 0 45.55 0 45.550001 5e-11 45.56 5e-11 \
    45.560001 0 45.6 0 45.600001 5e-11 45.61 5e-11 \
    45.610001 0 45.65 0 45.650001 5e-11 45.66 5e-11 \
    45.660001 0 45.7 0 45.700001 5e-11 45.71 5e-11 \
    45.710001 0 45.75 0 45.750001 5e-11 45.76 5e-11 \
    45.760001 0 45.8 0 45.800001 5e-11 45.81 5e-11 \
    45.810001 0 45.85 0 45.850001 5e-11 45.86 5e-11 \
    45.860001 0 45.9 0 45.900001 5e-11 45.91 5e-11 \
    45.910001 0 45.95 0 45.950001 5e-11 45.96 5e-11 \
    45.960001 0 46 0 46.000001 5e-11 46.01 5e-11 \
    46.010001 0 46.05 0 46.050001 5e-11 46.06 5e-11 \
    46.060001 0 46.1 0 46.100001 5e-11 46.11 5e-11 \
    46.110001 0 46.15 0 46.150001 5e-11 46.16 5e-11 \
    46.160001 0 46.2 0 46.200001 5e-11 46.21 5e-11 \
    46.210001 0 46.25 0 46.250001 5e-11 46.26 5e-11 \
    46.260001 0 46.3 0 46.300001 5e-11 46.31 5e-11 \
    46.310001 0 46.35 0 46.350001 5e-11 46.36 5e-11 \
    46.360001 0 46.4 0 46.400001 5e-11 46.41 5e-11 \
    46.410001 0 46.45 0 46.450001 5e-11 46.46 5e-11 \
    46.460001 0 46.5 0 46.500001 5e-11 46.51 5e-11 \
    46.510001 0 46.55 0 46.550001 5e-11 46.56 5e-11 \
    46.560001 0 46.6 0 46.600001 5e-11 46.61 5e-11 \
    46.610001 0 46.65 0 46.650001 5e-11 46.66 5e-11 \
    46.660001 0 46.7 0 46.700001 5e-11 46.71 5e-11 \
    46.710001 0 46.75 0 46.750001 5e-11 46.76 5e-11 \
    46.760001 0 46.8 0 46.800001 5e-11 46.81 5e-11 \
    46.810001 0 46.85 0 46.850001 5e-11 46.86 5e-11 \
    46.860001 0 46.9 0 46.900001 5e-11 46.91 5e-11 \
    46.910001 0 46.95 0 46.950001 5e-11 46.96 5e-11 \
    46.960001 0 47 0 47.000001 5e-11 47.01 5e-11 \
    47.010001 0 47.05 0 47.050001 5e-11 47.06 5e-11 \
    47.060001 0 47.1 0 47.100001 5e-11 47.11 5e-11 \
    47.110001 0 47.15 0 47.150001 5e-11 47.16 5e-11 \
    47.160001 0 47.2 0 47.200001 5e-11 47.21 5e-11 \
    47.210001 0 47.25 0 47.250001 5e-11 47.26 5e-11 \
    47.260001 0 47.3 0 47.300001 5e-11 47.31 5e-11 \
    47.310001 0 47.35 0 47.350001 5e-11 47.36 5e-11 \
    47.360001 0 47.4 0 47.400001 5e-11 47.41 5e-11 \
    47.410001 0 47.45 0 47.450001 5e-11 47.46 5e-11 \
    47.460001 0 47.5 0 47.500001 5e-11 47.51 5e-11 \
    47.510001 0 47.55 0 47.550001 5e-11 47.56 5e-11 \
    47.560001 0 47.6 0 47.600001 5e-11 47.61 5e-11 \
    47.610001 0 47.65 0 47.650001 5e-11 47.66 5e-11 \
    47.660001 0 47.7 0 47.700001 5e-11 47.71 5e-11 \
    47.710001 0 47.75 0 47.750001 5e-11 47.76 5e-11 \
    47.760001 0 47.8 0 47.800001 5e-11 47.81 5e-11 \
    47.810001 0 47.85 0 47.850001 5e-11 47.86 5e-11 \
    47.860001 0 47.9 0 47.900001 5e-11 47.91 5e-11 \
    47.910001 0 47.95 0 47.950001 5e-11 47.96 5e-11 \
    47.960001 0 48 0 48.000001 5e-11 48.01 5e-11 \
    48.010001 0 48.05 0 48.050001 5e-11 48.06 5e-11 \
    48.060001 0 48.1 0 48.100001 5e-11 48.11 5e-11 \
    48.110001 0 48.15 0 48.150001 5e-11 48.16 5e-11 \
    48.160001 0 48.2 0 48.200001 5e-11 48.21 5e-11 \
    48.210001 0 48.25 0 48.250001 5e-11 48.26 5e-11 \
    48.260001 0 48.3 0 48.300001 5e-11 48.31 5e-11 \
    48.310001 0 48.35 0 48.350001 5e-11 48.36 5e-11 \
    48.360001 0 48.4 0 48.400001 5e-11 48.41 5e-11 \
    48.410001 0 48.45 0 48.450001 5e-11 48.46 5e-11 \
    48.460001 0 48.5 0 48.500001 5e-11 48.51 5e-11 \
    48.510001 0 48.55 0 48.550001 5e-11 48.56 5e-11 \
    48.560001 0 48.6 0 48.600001 5e-11 48.61 5e-11 \
    48.610001 0 48.65 0 48.650001 5e-11 48.66 5e-11 \
    48.660001 0 48.7 0 48.700001 5e-11 48.71 5e-11 \
    48.710001 0 48.75 0 48.750001 5e-11 48.76 5e-11 \
    48.760001 0 48.8 0 48.800001 5e-11 48.81 5e-11 \
    48.810001 0 48.85 0 48.850001 5e-11 48.86 5e-11 \
    48.860001 0 48.9 0 48.900001 5e-11 48.91 5e-11 \
    48.910001 0 48.95 0 48.950001 5e-11 48.96 5e-11 \
    48.960001 0 49 0 49.000001 5e-11 49.01 5e-11 \
    49.010001 0 49.05 0 49.050001 5e-11 49.06 5e-11 \
    49.060001 0 49.1 0 49.100001 5e-11 49.11 5e-11 \
    49.110001 0 49.15 0 49.150001 5e-11 49.16 5e-11 \
    49.160001 0 49.2 0 49.200001 5e-11 49.21 5e-11 \
    49.210001 0 49.25 0 49.250001 5e-11 49.26 5e-11 \
    49.260001 0 49.3 0 49.300001 5e-11 49.31 5e-11 \
    49.310001 0 49.35 0 49.350001 5e-11 49.36 5e-11 \
    49.360001 0 49.4 0 49.400001 5e-11 49.41 5e-11 \
    49.410001 0 49.45 0 49.450001 5e-11 49.46 5e-11 \
    49.460001 0 49.5 0 49.500001 5e-11 49.51 5e-11 \
    49.510001 0 49.55 0 49.550001 5e-11 49.56 5e-11 \
    49.560001 0 49.6 0 49.600001 5e-11 49.61 5e-11 \
    49.610001 0 49.65 0 49.650001 5e-11 49.66 5e-11 \
    49.660001 0 49.7 0 49.700001 5e-11 49.71 5e-11 \
    49.710001 0 49.75 0 49.750001 5e-11 49.76 5e-11 \
    49.760001 0 49.8 0 49.800001 5e-11 49.81 5e-11 \
    49.810001 0 49.85 0 49.850001 5e-11 49.86 5e-11 \
    49.860001 0 49.9 0 49.900001 5e-11 49.91 5e-11 \
    49.910001 0 49.95 0 49.950001 5e-11 49.96 5e-11 \
    49.960001 0 50 0 50.000001 5e-11 50.01 5e-11 \
    50.010001 0 50.05 0 50.050001 5e-11 50.06 5e-11 \
    50.060001 0 50.1 0 50.100001 5e-11 50.11 5e-11 \
    50.110001 0 50.15 0 50.150001 5e-11 50.16 5e-11 \
    50.160001 0 50.2 0 50.200001 5e-11 50.21 5e-11 \
    50.210001 0 50.25 0 50.250001 5e-11 50.26 5e-11 \
    50.260001 0 50.3 0 50.300001 5e-11 50.31 5e-11 \
    50.310001 0 50.35 0 50.350001 5e-11 50.36 5e-11 \
    50.360001 0 50.4 0 50.400001 5e-11 50.41 5e-11 \
    50.410001 0 50.45 0 50.450001 5e-11 50.46 5e-11 \
    50.460001 0 50.5 0 50.500001 5e-11 50.51 5e-11 \
    50.510001 0 50.55 0 50.550001 5e-11 50.56 5e-11 \
    50.560001 0 50.6 0 50.600001 5e-11 50.61 5e-11 \
    50.610001 0 50.65 0 50.650001 5e-11 50.66 5e-11 \
    50.660001 0 50.7 0 50.700001 5e-11 50.71 5e-11 \
    50.710001 0 50.75 0 50.750001 5e-11 50.76 5e-11 \
    50.760001 0 50.8 0 50.800001 5e-11 50.81 5e-11 \
    50.810001 0 50.85 0 50.850001 5e-11 50.86 5e-11 \
    50.860001 0 50.9 0 50.900001 5e-11 50.91 5e-11 \
    50.910001 0 50.95 0 50.950001 5e-11 50.96 5e-11 \
    50.960001 0 51 0 51.000001 5e-11 51.01 5e-11 \
    51.010001 0 51.05 0 51.050001 5e-11 51.06 5e-11 \
    51.060001 0 51.1 0 51.100001 5e-11 51.11 5e-11 \
    51.110001 0 51.15 0 51.150001 5e-11 51.16 5e-11 \
    51.160001 0 51.2 0 51.200001 5e-11 51.21 5e-11 \
    51.210001 0 51.25 0 51.250001 5e-11 51.26 5e-11 \
    51.260001 0 51.3 0 51.300001 5e-11 51.31 5e-11 \
    51.310001 0 51.35 0 51.350001 5e-11 51.36 5e-11 \
    51.360001 0 51.4 0 51.400001 5e-11 51.41 5e-11 \
    51.410001 0 51.45 0 51.450001 5e-11 51.46 5e-11 \
    51.460001 0 51.5 0 51.500001 5e-11 51.51 5e-11 \
    51.510001 0 51.55 0 51.550001 5e-11 51.56 5e-11 \
    51.560001 0 51.6 0 51.600001 5e-11 51.61 5e-11 \
    51.610001 0 51.65 0 51.650001 5e-11 51.66 5e-11 \
    51.660001 0 51.7 0 51.700001 5e-11 51.71 5e-11 \
    51.710001 0 51.75 0 51.750001 5e-11 51.76 5e-11 \
    51.760001 0 51.8 0 51.800001 5e-11 51.81 5e-11 \
    51.810001 0 51.85 0 51.850001 5e-11 51.86 5e-11 \
    51.860001 0 51.9 0 51.900001 5e-11 51.91 5e-11 \
    51.910001 0 51.95 0 51.950001 5e-11 51.96 5e-11 \
    51.960001 0 52 0 52.000001 5e-11 52.01 5e-11 \
    52.010001 0 52.05 0 52.050001 5e-11 52.06 5e-11 \
    52.060001 0 52.1 0 52.100001 5e-11 52.11 5e-11 \
    52.110001 0 52.15 0 52.150001 5e-11 52.16 5e-11 \
    52.160001 0 52.2 0 52.200001 5e-11 52.21 5e-11 \
    52.210001 0 52.25 0 52.250001 5e-11 52.26 5e-11 \
    52.260001 0 52.3 0 52.300001 5e-11 52.31 5e-11 \
    52.310001 0 52.35 0 52.350001 5e-11 52.36 5e-11 \
    52.360001 0 52.4 0 52.400001 5e-11 52.41 5e-11 \
    52.410001 0 52.45 0 52.450001 5e-11 52.46 5e-11 \
    52.460001 0 52.5 0 52.500001 5e-11 52.51 5e-11 \
    52.510001 0 52.55 0 52.550001 5e-11 52.56 5e-11 \
    52.560001 0 52.6 0 52.600001 5e-11 52.61 5e-11 \
    52.610001 0 52.65 0 52.650001 5e-11 52.66 5e-11 \
    52.660001 0 52.7 0 52.700001 5e-11 52.71 5e-11 \
    52.710001 0 52.75 0 52.750001 5e-11 52.76 5e-11 \
    52.760001 0 52.8 0 52.800001 5e-11 52.81 5e-11 \
    52.810001 0 52.85 0 52.850001 5e-11 52.86 5e-11 \
    52.860001 0 52.9 0 52.900001 5e-11 52.91 5e-11 \
    52.910001 0 52.95 0 52.950001 5e-11 52.96 5e-11 \
    52.960001 0 53 0 53.000001 5e-11 53.01 5e-11 \
    53.010001 0 53.05 0 53.050001 5e-11 53.06 5e-11 \
    53.060001 0 53.1 0 53.100001 5e-11 53.11 5e-11 \
    53.110001 0 53.15 0 53.150001 5e-11 53.16 5e-11 \
    53.160001 0 53.2 0 53.200001 5e-11 53.21 5e-11 \
    53.210001 0 53.25 0 53.250001 5e-11 53.26 5e-11 \
    53.260001 0 53.3 0 53.300001 5e-11 53.31 5e-11 \
    53.310001 0 53.35 0 53.350001 5e-11 53.36 5e-11 \
    53.360001 0 53.4 0 53.400001 5e-11 53.41 5e-11 \
    53.410001 0 53.45 0 53.450001 5e-11 53.46 5e-11 \
    53.460001 0 53.5 0 53.500001 5e-11 53.51 5e-11 \
    53.510001 0 53.55 0 53.550001 5e-11 53.56 5e-11 \
    53.560001 0 53.6 0 53.600001 5e-11 53.61 5e-11 \
    53.610001 0 53.65 0 53.650001 5e-11 53.66 5e-11 \
    53.660001 0 53.7 0 53.700001 5e-11 53.71 5e-11 \
    53.710001 0 53.75 0 53.750001 5e-11 53.76 5e-11 \
    53.760001 0 53.8 0 53.800001 5e-11 53.81 5e-11 \
    53.810001 0 53.85 0 53.850001 5e-11 53.86 5e-11 \
    53.860001 0 53.9 0 53.900001 5e-11 53.91 5e-11 \
    53.910001 0 53.95 0 53.950001 5e-11 53.96 5e-11 \
    53.960001 0 54 0 54.000001 5e-11 54.01 5e-11 \
    54.010001 0 54.05 0 54.050001 5e-11 54.06 5e-11 \
    54.060001 0 54.1 0 54.100001 5e-11 54.11 5e-11 \
    54.110001 0 54.15 0 54.150001 5e-11 54.16 5e-11 \
    54.160001 0 54.2 0 54.200001 5e-11 54.21 5e-11 \
    54.210001 0 54.25 0 54.250001 5e-11 54.26 5e-11 \
    54.260001 0 54.3 0 54.300001 5e-11 54.31 5e-11 \
    54.310001 0 54.35 0 54.350001 5e-11 54.36 5e-11 \
    54.360001 0 54.4 0 54.400001 5e-11 54.41 5e-11 \
    54.410001 0 54.45 0 54.450001 5e-11 54.46 5e-11 \
    54.460001 0 54.5 0 54.500001 5e-11 54.51 5e-11 \
    54.510001 0 54.55 0 54.550001 5e-11 54.56 5e-11 \
    54.560001 0 54.6 0 54.600001 5e-11 54.61 5e-11 \
    54.610001 0 54.65 0 54.650001 5e-11 54.66 5e-11 \
    54.660001 0 54.7 0 54.700001 5e-11 54.71 5e-11 \
    54.710001 0 54.75 0 54.750001 5e-11 54.76 5e-11 \
    54.760001 0 54.8 0 54.800001 5e-11 54.81 5e-11 \
    54.810001 0 54.85 0 54.850001 5e-11 54.86 5e-11 \
    54.860001 0 54.9 0 54.900001 5e-11 54.91 5e-11 \
    54.910001 0 54.95 0 54.950001 5e-11 54.96 5e-11 \
    54.960001 0 55 0 55.000001 5e-11 55.01 5e-11 \
    55.010001 0 55.05 0 55.050001 5e-11 55.06 5e-11 \
    55.060001 0 55.1 0 55.100001 5e-11 55.11 5e-11 \
    55.110001 0 55.15 0 55.150001 5e-11 55.16 5e-11 \
    55.160001 0 55.2 0 55.200001 5e-11 55.21 5e-11 \
    55.210001 0 55.25 0 55.250001 5e-11 55.26 5e-11 \
    55.260001 0 55.3 0 55.300001 5e-11 55.31 5e-11 \
    55.310001 0 55.35 0 55.350001 5e-11 55.36 5e-11 \
    55.360001 0 55.4 0 55.400001 5e-11 55.41 5e-11 \
    55.410001 0 55.45 0 55.450001 5e-11 55.46 5e-11 \
    55.460001 0 55.5 0 55.500001 5e-11 55.51 5e-11 \
    55.510001 0 55.55 0 55.550001 5e-11 55.56 5e-11 \
    55.560001 0 55.6 0 55.600001 5e-11 55.61 5e-11 \
    55.610001 0 55.65 0 55.650001 5e-11 55.66 5e-11 \
    55.660001 0 55.7 0 55.700001 5e-11 55.71 5e-11 \
    55.710001 0 55.75 0 55.750001 5e-11 55.76 5e-11 \
    55.760001 0 55.8 0 55.800001 5e-11 55.81 5e-11 \
    55.810001 0 55.85 0 55.850001 5e-11 55.86 5e-11 \
    55.860001 0 55.9 0 55.900001 5e-11 55.91 5e-11 \
    55.910001 0 55.95 0 55.950001 5e-11 55.96 5e-11 \
    55.960001 0 56 0 56.000001 5e-11 56.01 5e-11 \
    56.010001 0 56.05 0 56.050001 5e-11 56.06 5e-11 \
    56.060001 0 56.1 0 56.100001 5e-11 56.11 5e-11 \
    56.110001 0 56.15 0 56.150001 5e-11 56.16 5e-11 \
    56.160001 0 56.2 0 56.200001 5e-11 56.21 5e-11 \
    56.210001 0 56.25 0 56.250001 5e-11 56.26 5e-11 \
    56.260001 0 56.3 0 56.300001 5e-11 56.31 5e-11 \
    56.310001 0 56.35 0 56.350001 5e-11 56.36 5e-11 \
    56.360001 0 56.4 0 56.400001 5e-11 56.41 5e-11 \
    56.410001 0 56.45 0 56.450001 5e-11 56.46 5e-11 \
    56.460001 0 56.5 0 56.500001 5e-11 56.51 5e-11 \
    56.510001 0 56.55 0 56.550001 5e-11 56.56 5e-11 \
    56.560001 0 56.6 0 56.600001 5e-11 56.61 5e-11 \
    56.610001 0 56.65 0 56.650001 5e-11 56.66 5e-11 \
    56.660001 0 56.7 0 56.700001 5e-11 56.71 5e-11 \
    56.710001 0 56.75 0 56.750001 5e-11 56.76 5e-11 \
    56.760001 0 56.8 0 56.800001 5e-11 56.81 5e-11 \
    56.810001 0 56.85 0 56.850001 5e-11 56.86 5e-11 \
    56.860001 0 56.9 0 56.900001 5e-11 56.91 5e-11 \
    56.910001 0 56.95 0 56.950001 5e-11 56.96 5e-11 \
    56.960001 0 57 0 57.000001 5e-11 57.01 5e-11 \
    57.010001 0 57.05 0 57.050001 5e-11 57.06 5e-11 \
    57.060001 0 57.1 0 57.100001 5e-11 57.11 5e-11 \
    57.110001 0 57.15 0 57.150001 5e-11 57.16 5e-11 \
    57.160001 0 57.2 0 57.200001 5e-11 57.21 5e-11 \
    57.210001 0 57.25 0 57.250001 5e-11 57.26 5e-11 \
    57.260001 0 57.3 0 57.300001 5e-11 57.31 5e-11 \
    57.310001 0 57.35 0 57.350001 5e-11 57.36 5e-11 \
    57.360001 0 57.4 0 57.400001 5e-11 57.41 5e-11 \
    57.410001 0 57.45 0 57.450001 5e-11 57.46 5e-11 \
    57.460001 0 57.5 0 57.500001 5e-11 57.51 5e-11 \
    57.510001 0 57.55 0 57.550001 5e-11 57.56 5e-11 \
    57.560001 0 57.6 0 57.600001 5e-11 57.61 5e-11 \
    57.610001 0 57.65 0 57.650001 5e-11 57.66 5e-11 \
    57.660001 0 57.7 0 57.700001 5e-11 57.71 5e-11 \
    57.710001 0 57.75 0 57.750001 5e-11 57.76 5e-11 \
    57.760001 0 57.8 0 57.800001 5e-11 57.81 5e-11 \
    57.810001 0 57.85 0 57.850001 5e-11 57.86 5e-11 \
    57.860001 0 57.9 0 57.900001 5e-11 57.91 5e-11 \
    57.910001 0 57.95 0 57.950001 5e-11 57.96 5e-11 \
    57.960001 0 58 0 58.000001 5e-11 58.01 5e-11 \
    58.010001 0 58.05 0 58.050001 5e-11 58.06 5e-11 \
    58.060001 0 58.1 0 58.100001 5e-11 58.11 5e-11 \
    58.110001 0 58.15 0 58.150001 5e-11 58.16 5e-11 \
    58.160001 0 58.2 0 58.200001 5e-11 58.21 5e-11 \
    58.210001 0 58.25 0 58.250001 5e-11 58.26 5e-11 \
    58.260001 0 58.3 0 58.300001 5e-11 58.31 5e-11 \
    58.310001 0 58.35 0 58.350001 5e-11 58.36 5e-11 \
    58.360001 0 58.4 0 58.400001 5e-11 58.41 5e-11 \
    58.410001 0 58.45 0 58.450001 5e-11 58.46 5e-11 \
    58.460001 0 58.5 0 58.500001 5e-11 58.51 5e-11 \
    58.510001 0 58.55 0 58.550001 5e-11 58.56 5e-11 \
    58.560001 0 58.6 0 58.600001 5e-11 58.61 5e-11 \
    58.610001 0 58.65 0 58.650001 5e-11 58.66 5e-11 \
    58.660001 0 58.7 0 58.700001 5e-11 58.71 5e-11 \
    58.710001 0 58.75 0 58.750001 5e-11 58.76 5e-11 \
    58.760001 0 58.8 0 58.800001 5e-11 58.81 5e-11 \
    58.810001 0 58.85 0 58.850001 5e-11 58.86 5e-11 \
    58.860001 0 58.9 0 58.900001 5e-11 58.91 5e-11 \
    58.910001 0 58.95 0 58.950001 5e-11 58.96 5e-11 \
    58.960001 0 59 0 59.000001 5e-11 59.01 5e-11 \
    59.010001 0 59.05 0 59.050001 5e-11 59.06 5e-11 \
    59.060001 0 59.1 0 59.100001 5e-11 59.11 5e-11 \
    59.110001 0 59.15 0 59.150001 5e-11 59.16 5e-11 \
    59.160001 0 59.2 0 59.200001 5e-11 59.21 5e-11 \
    59.210001 0 59.25 0 59.250001 5e-11 59.26 5e-11 \
    59.260001 0 59.3 0 59.300001 5e-11 59.31 5e-11 \
    59.310001 0 59.35 0 59.350001 5e-11 59.36 5e-11 \
    59.360001 0 59.4 0 59.400001 5e-11 59.41 5e-11 \
    59.410001 0 59.45 0 59.450001 5e-11 59.46 5e-11 \
    59.460001 0 59.5 0 59.500001 5e-11 59.51 5e-11 \
    59.510001 0 59.55 0 59.550001 5e-11 59.56 5e-11 \
    59.560001 0 59.6 0 59.600001 5e-11 59.61 5e-11 \
    59.610001 0 59.65 0 59.650001 5e-11 59.66 5e-11 \
    59.660001 0 59.7 0 59.700001 5e-11 59.71 5e-11 \
    59.710001 0 59.75 0 59.750001 5e-11 59.76 5e-11 \
    59.760001 0 59.8 0 59.800001 5e-11 59.81 5e-11 \
    59.810001 0 59.85 0 59.850001 5e-11 59.86 5e-11 \
    59.860001 0 59.9 0 59.900001 5e-11 59.91 5e-11 \
    59.910001 0 59.95 0 59.950001 5e-11 59.96 5e-11 \
    59.960001 0 60 0 60.000001 5e-11 60.01 5e-11 \
    60.010001 0 60.05 0 60.050001 5e-11 60.06 5e-11 \
    60.060001 0 60.1 0 60.100001 5e-11 60.11 5e-11 \
    60.110001 0 60.15 0 60.150001 5e-11 60.16 5e-11 \
    60.160001 0 60.2 0 60.200001 5e-11 60.21 5e-11 \
    60.210001 0 60.25 0 60.250001 5e-11 60.26 5e-11 \
    60.260001 0 60.3 0 60.300001 5e-11 60.31 5e-11 \
    60.310001 0 60.35 0 60.350001 5e-11 60.36 5e-11 \
    60.360001 0 60.4 0 60.400001 5e-11 60.41 5e-11 \
    60.410001 0 60.45 0 60.450001 5e-11 60.46 5e-11 \
    60.460001 0 60.5 0 60.500001 5e-11 60.51 5e-11 \
    60.510001 0 60.55 0 60.550001 5e-11 60.56 5e-11 \
    60.560001 0 60.6 0 60.600001 5e-11 60.61 5e-11 \
    60.610001 0 60.65 0 60.650001 5e-11 60.66 5e-11 \
    60.660001 0 60.7 0 60.700001 5e-11 60.71 5e-11 \
    60.710001 0 60.75 0 60.750001 5e-11 60.76 5e-11 \
    60.760001 0 60.8 0 60.800001 5e-11 60.81 5e-11 \
    60.810001 0 60.85 0 60.850001 5e-11 60.86 5e-11 \
    60.860001 0 60.9 0 60.900001 5e-11 60.91 5e-11 \
    60.910001 0 60.95 0 60.950001 5e-11 60.96 5e-11 \
    60.960001 0 61 0 61.000001 5e-11 61.01 5e-11 \
    61.010001 0 61.05 0 61.050001 5e-11 61.06 5e-11 \
    61.060001 0 61.1 0 61.100001 5e-11 61.11 5e-11 \
    61.110001 0 61.15 0 61.150001 5e-11 61.16 5e-11 \
    61.160001 0 61.2 0 61.200001 5e-11 61.21 5e-11 \
    61.210001 0 61.25 0 61.250001 5e-11 61.26 5e-11 \
    61.260001 0 61.3 0 61.300001 5e-11 61.31 5e-11 \
    61.310001 0 61.35 0 61.350001 5e-11 61.36 5e-11 \
    61.360001 0 61.4 0 61.400001 5e-11 61.41 5e-11 \
    61.410001 0 61.45 0 61.450001 5e-11 61.46 5e-11 \
    61.460001 0 61.5 0 61.500001 5e-11 61.51 5e-11 \
    61.510001 0 61.55 0 61.550001 5e-11 61.56 5e-11 \
    61.560001 0 61.6 0 61.600001 5e-11 61.61 5e-11 \
    61.610001 0 61.65 0 61.650001 5e-11 61.66 5e-11 \
    61.660001 0 61.7 0 61.700001 5e-11 61.71 5e-11 \
    61.710001 0 61.75 0 61.750001 5e-11 61.76 5e-11 \
    61.760001 0 61.8 0 61.800001 5e-11 61.81 5e-11 \
    61.810001 0 61.85 0 61.850001 5e-11 61.86 5e-11 \
    61.860001 0 61.9 0 61.900001 5e-11 61.91 5e-11 \
    61.910001 0 61.95 0 61.950001 5e-11 61.96 5e-11 \
    61.960001 0 62 0 62.000001 5e-11 62.01 5e-11 \
    62.010001 0 62.05 0 62.050001 5e-11 62.06 5e-11 \
    62.060001 0 62.1 0 62.100001 5e-11 62.11 5e-11 \
    62.110001 0 62.15 0 62.150001 5e-11 62.16 5e-11 \
    62.160001 0 62.2 0 62.200001 5e-11 62.21 5e-11 \
    62.210001 0 62.25 0 62.250001 5e-11 62.26 5e-11 \
    62.260001 0 62.3 0 62.300001 5e-11 62.31 5e-11 \
    62.310001 0 62.35 0 62.350001 5e-11 62.36 5e-11 \
    62.360001 0 62.4 0 62.400001 5e-11 62.41 5e-11 \
    62.410001 0 62.45 0 62.450001 5e-11 62.46 5e-11 \
    62.460001 0 62.5 0 62.500001 5e-11 62.51 5e-11 \
    62.510001 0 62.55 0 62.550001 5e-11 62.56 5e-11 \
    62.560001 0 62.6 0 62.600001 5e-11 62.61 5e-11 \
    62.610001 0 62.65 0 62.650001 5e-11 62.66 5e-11 \
    62.660001 0 62.7 0 62.700001 5e-11 62.71 5e-11 \
    62.710001 0 62.75 0 62.750001 5e-11 62.76 5e-11 \
    62.760001 0 62.8 0 62.800001 5e-11 62.81 5e-11 \
    62.810001 0 62.85 0 62.850001 5e-11 62.86 5e-11 \
    62.860001 0 62.9 0 62.900001 5e-11 62.91 5e-11 \
    62.910001 0 62.95 0 62.950001 5e-11 62.96 5e-11 \
    62.960001 0 63 0 63.000001 5e-11 63.01 5e-11 \
    63.010001 0 63.05 0 63.050001 5e-11 63.06 5e-11 \
    63.060001 0 63.1 0 63.100001 5e-11 63.11 5e-11 \
    63.110001 0 63.15 0 63.150001 5e-11 63.16 5e-11 \
    63.160001 0 63.2 0 63.200001 5e-11 63.21 5e-11 \
    63.210001 0 63.25 0 63.250001 5e-11 63.26 5e-11 \
    63.260001 0 63.3 0 63.300001 5e-11 63.31 5e-11 \
    63.310001 0 63.35 0 63.350001 5e-11 63.36 5e-11 \
    63.360001 0 63.4 0 63.400001 5e-11 63.41 5e-11 \
    63.410001 0 63.45 0 63.450001 5e-11 63.46 5e-11 \
    63.460001 0 63.5 0 63.500001 5e-11 63.51 5e-11 \
    63.510001 0 63.55 0 63.550001 5e-11 63.56 5e-11 \
    63.560001 0 63.6 0 63.600001 5e-11 63.61 5e-11 \
    63.610001 0 63.65 0 63.650001 5e-11 63.66 5e-11 \
    63.660001 0 63.7 0 63.700001 5e-11 63.71 5e-11 \
    63.710001 0 63.75 0 63.750001 5e-11 63.76 5e-11 \
    63.760001 0 63.8 0 63.800001 5e-11 63.81 5e-11 \
    63.810001 0 63.85 0 63.850001 5e-11 63.86 5e-11 \
    63.860001 0 63.9 0 63.900001 5e-11 63.91 5e-11 \
    63.910001 0 63.95 0 63.950001 5e-11 63.96 5e-11 \
    63.960001 0 64 0 64.000001 5e-11 64.01 5e-11 \
    64.010001 0 64.05 0 64.050001 5e-11 64.06 5e-11 \
    64.060001 0 64.1 0 64.100001 5e-11 64.11 5e-11 \
    64.110001 0 64.15 0 64.150001 5e-11 64.16 5e-11 \
    64.160001 0 64.2 0 64.200001 5e-11 64.21 5e-11 \
    64.210001 0 64.25 0 64.250001 5e-11 64.26 5e-11 \
    64.260001 0 64.3 0 64.300001 5e-11 64.31 5e-11 \
    64.310001 0 64.35 0 64.350001 5e-11 64.36 5e-11 \
    64.360001 0 64.4 0 64.400001 5e-11 64.41 5e-11 \
    64.410001 0 64.45 0 64.450001 5e-11 64.46 5e-11 \
    64.460001 0 64.5 0 64.500001 5e-11 64.51 5e-11 \
    64.510001 0 64.55 0 64.550001 5e-11 64.56 5e-11 \
    64.560001 0 64.6 0 64.600001 5e-11 64.61 5e-11 \
    64.610001 0 64.65 0 64.650001 5e-11 64.66 5e-11 \
    64.660001 0 64.7 0 64.700001 5e-11 64.71 5e-11 \
    64.710001 0 64.75 0 64.750001 5e-11 64.76 5e-11 \
    64.760001 0 64.8 0 64.800001 5e-11 64.81 5e-11 \
    64.810001 0 64.85 0 64.850001 5e-11 64.86 5e-11 \
    64.860001 0 64.9 0 64.900001 5e-11 64.91 5e-11 \
    64.910001 0 64.95 0 64.950001 5e-11 64.96 5e-11 \
    64.960001 0 65 0 65.000001 5e-11 65.01 5e-11 \
    65.010001 0 65.05 0 65.050001 5e-11 65.06 5e-11 \
    65.060001 0 65.1 0 65.100001 5e-11 65.11 5e-11 \
    65.110001 0 65.15 0 65.150001 5e-11 65.16 5e-11 \
    65.160001 0 65.2 0 65.200001 5e-11 65.21 5e-11 \
    65.210001 0 65.25 0 65.250001 5e-11 65.26 5e-11 \
    65.260001 0 65.3 0 65.300001 5e-11 65.31 5e-11 \
    65.310001 0 65.35 0 65.350001 5e-11 65.36 5e-11 \
    65.360001 0 65.4 0 65.400001 5e-11 65.41 5e-11 \
    65.410001 0 65.45 0 65.450001 5e-11 65.46 5e-11 \
    65.460001 0 65.5 0 65.500001 5e-11 65.51 5e-11 \
    65.510001 0 65.55 0 65.550001 5e-11 65.56 5e-11 \
    65.560001 0 65.6 0 65.600001 5e-11 65.61 5e-11 \
    65.610001 0 65.65 0 65.650001 5e-11 65.66 5e-11 \
    65.660001 0 65.7 0 65.700001 5e-11 65.71 5e-11 \
    65.710001 0 65.75 0 65.750001 5e-11 65.76 5e-11 \
    65.760001 0 65.8 0 65.800001 5e-11 65.81 5e-11 \
    65.810001 0 65.85 0 65.850001 5e-11 65.86 5e-11 \
    65.860001 0 65.9 0 65.900001 5e-11 65.91 5e-11 \
    65.910001 0 65.95 0 65.950001 5e-11 65.96 5e-11 \
    65.960001 0 66 0 66.000001 5e-11 66.01 5e-11 \
    66.010001 0 66.05 0 66.050001 5e-11 66.06 5e-11 \
    66.060001 0 66.1 0 66.100001 5e-11 66.11 5e-11 \
    66.110001 0 66.15 0 66.150001 5e-11 66.16 5e-11 \
    66.160001 0 66.2 0 66.200001 5e-11 66.21 5e-11 \
    66.210001 0 66.25 0 66.250001 5e-11 66.26 5e-11 \
    66.260001 0 66.3 0 66.300001 5e-11 66.31 5e-11 \
    66.310001 0 66.35 0 66.350001 5e-11 66.36 5e-11 \
    66.360001 0 66.4 0 66.400001 5e-11 66.41 5e-11 \
    66.410001 0 66.45 0 66.450001 5e-11 66.46 5e-11 \
    66.460001 0 66.5 0 66.500001 5e-11 66.51 5e-11 \
    66.510001 0 66.55 0 66.550001 5e-11 66.56 5e-11 \
    66.560001 0 66.6 0 66.600001 5e-11 66.61 5e-11 \
    66.610001 0 66.65 0 66.650001 5e-11 66.66 5e-11 \
    66.660001 0 66.7 0 66.700001 5e-11 66.71 5e-11 \
    66.710001 0 66.75 0 66.750001 5e-11 66.76 5e-11 \
    66.760001 0 66.8 0 66.800001 5e-11 66.81 5e-11 \
    66.810001 0 66.85 0 66.850001 5e-11 66.86 5e-11 \
    66.860001 0 66.9 0 66.900001 5e-11 66.91 5e-11 \
    66.910001 0 66.95 0 66.950001 5e-11 66.96 5e-11 \
    66.960001 0 67 0 67.000001 5e-11 67.01 5e-11 \
    67.010001 0 67.05 0 67.050001 5e-11 67.06 5e-11 \
    67.060001 0 67.1 0 67.100001 5e-11 67.11 5e-11 \
    67.110001 0 67.15 0 67.150001 5e-11 67.16 5e-11 \
    67.160001 0 67.2 0 67.200001 5e-11 67.21 5e-11 \
    67.210001 0 67.25 0 67.250001 5e-11 67.26 5e-11 \
    67.260001 0 67.3 0 67.300001 5e-11 67.31 5e-11 \
    67.310001 0 67.35 0 67.350001 5e-11 67.36 5e-11 \
    67.360001 0 67.4 0 67.400001 5e-11 67.41 5e-11 \
    67.410001 0 67.45 0 67.450001 5e-11 67.46 5e-11 \
    67.460001 0 67.5 0 67.500001 5e-11 67.51 5e-11 \
    67.510001 0 67.55 0 67.550001 5e-11 67.56 5e-11 \
    67.560001 0 67.6 0 67.600001 5e-11 67.61 5e-11 \
    67.610001 0 67.65 0 67.650001 5e-11 67.66 5e-11 \
    67.660001 0 67.7 0 67.700001 5e-11 67.71 5e-11 \
    67.710001 0 67.75 0 67.750001 5e-11 67.76 5e-11 \
    67.760001 0 67.8 0 67.800001 5e-11 67.81 5e-11 \
    67.810001 0 67.85 0 67.850001 5e-11 67.86 5e-11 \
    67.860001 0 67.9 0 67.900001 5e-11 67.91 5e-11 \
    67.910001 0 67.95 0 67.950001 5e-11 67.96 5e-11 \
    67.960001 0 68 0 68.000001 5e-11 68.01 5e-11 \
    68.010001 0 68.05 0 68.050001 5e-11 68.06 5e-11 \
    68.060001 0 68.1 0 68.100001 5e-11 68.11 5e-11 \
    68.110001 0 68.15 0 68.150001 5e-11 68.16 5e-11 \
    68.160001 0 68.2 0 68.200001 5e-11 68.21 5e-11 \
    68.210001 0 68.25 0 68.250001 5e-11 68.26 5e-11 \
    68.260001 0 68.3 0 68.300001 5e-11 68.31 5e-11 \
    68.310001 0 68.35 0 68.350001 5e-11 68.36 5e-11 \
    68.360001 0 68.4 0 68.400001 5e-11 68.41 5e-11 \
    68.410001 0 68.45 0 68.450001 5e-11 68.46 5e-11 \
    68.460001 0 68.5 0 68.500001 5e-11 68.51 5e-11 \
    68.510001 0 68.55 0 68.550001 5e-11 68.56 5e-11 \
    68.560001 0 68.6 0 68.600001 5e-11 68.61 5e-11 \
    68.610001 0 68.65 0 68.650001 5e-11 68.66 5e-11 \
    68.660001 0 68.7 0 68.700001 5e-11 68.71 5e-11 \
    68.710001 0 68.75 0 68.750001 5e-11 68.76 5e-11 \
    68.760001 0 68.8 0 68.800001 5e-11 68.81 5e-11 \
    68.810001 0 68.85 0 68.850001 5e-11 68.86 5e-11 \
    68.860001 0 68.9 0 68.900001 5e-11 68.91 5e-11 \
    68.910001 0 68.95 0 68.950001 5e-11 68.96 5e-11 \
    68.960001 0 69 0 69.000001 5e-11 69.01 5e-11 \
    69.010001 0 69.05 0 69.050001 5e-11 69.06 5e-11 \
    69.060001 0 69.1 0 69.100001 5e-11 69.11 5e-11 \
    69.110001 0 69.15 0 69.150001 5e-11 69.16 5e-11 \
    69.160001 0 69.2 0 69.200001 5e-11 69.21 5e-11 \
    69.210001 0 69.25 0 69.250001 5e-11 69.26 5e-11 \
    69.260001 0 69.3 0 69.300001 5e-11 69.31 5e-11 \
    69.310001 0 69.35 0 69.350001 5e-11 69.36 5e-11 \
    69.360001 0 69.4 0 69.400001 5e-11 69.41 5e-11 \
    69.410001 0 69.45 0 69.450001 5e-11 69.46 5e-11 \
    69.460001 0 69.5 0 69.500001 5e-11 69.51 5e-11 \
    69.510001 0 69.55 0 69.550001 5e-11 69.56 5e-11 \
    69.560001 0 69.6 0 69.600001 5e-11 69.61 5e-11 \
    69.610001 0 69.65 0 69.650001 5e-11 69.66 5e-11 \
    69.660001 0 69.7 0 69.700001 5e-11 69.71 5e-11 \
    69.710001 0 69.75 0 69.750001 5e-11 69.76 5e-11 \
    69.760001 0 69.8 0 69.800001 5e-11 69.81 5e-11 \
    69.810001 0 69.85 0 69.850001 5e-11 69.86 5e-11 \
    69.860001 0 69.9 0 69.900001 5e-11 69.91 5e-11 \
    69.910001 0 69.95 0 69.950001 5e-11 69.96 5e-11 \
    69.960001 0 70 0 70.000001 5e-11 70.01 5e-11 \
    70.010001 0 70.05 0 70.050001 5e-11 70.06 5e-11 \
    70.060001 0 70.1 0 70.100001 5e-11 70.11 5e-11 \
    70.110001 0 70.15 0 70.150001 5e-11 70.16 5e-11 \
    70.160001 0 70.2 0 70.200001 5e-11 70.21 5e-11 \
    70.210001 0 70.25 0 70.250001 5e-11 70.26 5e-11 \
    70.260001 0 70.3 0 70.300001 5e-11 70.31 5e-11 \
    70.310001 0 70.35 0 70.350001 5e-11 70.36 5e-11 \
    70.360001 0 70.4 0 70.400001 5e-11 70.41 5e-11 \
    70.410001 0 70.45 0 70.450001 5e-11 70.46 5e-11 \
    70.460001 0 70.5 0 70.500001 5e-11 70.51 5e-11 \
    70.510001 0 70.55 0 70.550001 5e-11 70.56 5e-11 \
    70.560001 0 70.6 0 70.600001 5e-11 70.61 5e-11 \
    70.610001 0 70.65 0 70.650001 5e-11 70.66 5e-11 \
    70.660001 0 70.7 0 70.700001 5e-11 70.71 5e-11 \
    70.710001 0 70.75 0 70.750001 5e-11 70.76 5e-11 \
    70.760001 0 70.8 0 70.800001 5e-11 70.81 5e-11 \
    70.810001 0 70.85 0 70.850001 5e-11 70.86 5e-11 \
    70.860001 0 70.9 0 70.900001 5e-11 70.91 5e-11 \
    70.910001 0 70.95 0 70.950001 5e-11 70.96 5e-11 \
    70.960001 0 71 0 71.000001 5e-11 71.01 5e-11 \
    71.010001 0 71.05 0 71.050001 5e-11 71.06 5e-11 \
    71.060001 0 71.1 0 71.100001 5e-11 71.11 5e-11 \
    71.110001 0 71.15 0 71.150001 5e-11 71.16 5e-11 \
    71.160001 0 71.2 0 71.200001 5e-11 71.21 5e-11 \
    71.210001 0 71.25 0 71.250001 5e-11 71.26 5e-11 \
    71.260001 0 71.3 0 71.300001 5e-11 71.31 5e-11 \
    71.310001 0 71.35 0 71.350001 5e-11 71.36 5e-11 \
    71.360001 0 71.4 0 71.400001 5e-11 71.41 5e-11 \
    71.410001 0 71.45 0 71.450001 5e-11 71.46 5e-11 \
    71.460001 0 71.5 0 71.500001 5e-11 71.51 5e-11 \
    71.510001 0 71.55 0 71.550001 5e-11 71.56 5e-11 \
    71.560001 0 71.6 0 71.600001 5e-11 71.61 5e-11 \
    71.610001 0 71.65 0 71.650001 5e-11 71.66 5e-11 \
    71.660001 0 71.7 0 71.700001 5e-11 71.71 5e-11 \
    71.710001 0 71.75 0 71.750001 5e-11 71.76 5e-11 \
    71.760001 0 71.8 0 71.800001 5e-11 71.81 5e-11 \
    71.810001 0 71.85 0 71.850001 5e-11 71.86 5e-11 \
    71.860001 0 71.9 0 71.900001 5e-11 71.91 5e-11 \
    71.910001 0 71.95 0 71.950001 5e-11 71.96 5e-11 \
    71.960001 0 72 0 72.000001 5e-11 72.01 5e-11 \
    72.010001 0 72.05 0 72.050001 5e-11 72.06 5e-11 \
    72.060001 0 72.1 0 72.100001 5e-11 72.11 5e-11 \
    72.110001 0 72.15 0 72.150001 5e-11 72.16 5e-11 \
    72.160001 0 72.2 0 72.200001 5e-11 72.21 5e-11 \
    72.210001 0 72.25 0 72.250001 5e-11 72.26 5e-11 \
    72.260001 0 72.3 0 72.300001 5e-11 72.31 5e-11 \
    72.310001 0 72.35 0 72.350001 5e-11 72.36 5e-11 \
    72.360001 0 72.4 0 72.400001 5e-11 72.41 5e-11 \
    72.410001 0 72.45 0 72.450001 5e-11 72.46 5e-11 \
    72.460001 0 72.5 0 72.500001 5e-11 72.51 5e-11 \
    72.510001 0 72.55 0 72.550001 5e-11 72.56 5e-11 \
    72.560001 0 72.6 0 72.600001 5e-11 72.61 5e-11 \
    72.610001 0 72.65 0 72.650001 5e-11 72.66 5e-11 \
    72.660001 0 72.7 0 72.700001 5e-11 72.71 5e-11 \
    72.710001 0 72.75 0 72.750001 5e-11 72.76 5e-11 \
    72.760001 0 72.8 0 72.800001 5e-11 72.81 5e-11 \
    72.810001 0 72.85 0 72.850001 5e-11 72.86 5e-11 \
    72.860001 0 72.9 0 72.900001 5e-11 72.91 5e-11 \
    72.910001 0 72.95 0 72.950001 5e-11 72.96 5e-11 \
    72.960001 0 73 0 73.000001 5e-11 73.01 5e-11 \
    73.010001 0 73.05 0 73.050001 5e-11 73.06 5e-11 \
    73.060001 0 73.1 0 73.100001 5e-11 73.11 5e-11 \
    73.110001 0 73.15 0 73.150001 5e-11 73.16 5e-11 \
    73.160001 0 73.2 0 73.200001 5e-11 73.21 5e-11 \
    73.210001 0 73.25 0 73.250001 5e-11 73.26 5e-11 \
    73.260001 0 73.3 0 73.300001 5e-11 73.31 5e-11 \
    73.310001 0 73.35 0 73.350001 5e-11 73.36 5e-11 \
    73.360001 0 73.4 0 73.400001 5e-11 73.41 5e-11 \
    73.410001 0 73.45 0 73.450001 5e-11 73.46 5e-11 \
    73.460001 0 73.5 0 73.500001 5e-11 73.51 5e-11 \
    73.510001 0 73.55 0 73.550001 5e-11 73.56 5e-11 \
    73.560001 0 73.6 0 73.600001 5e-11 73.61 5e-11 \
    73.610001 0 73.65 0 73.650001 5e-11 73.66 5e-11 \
    73.660001 0 73.7 0 73.700001 5e-11 73.71 5e-11 \
    73.710001 0 73.75 0 73.750001 5e-11 73.76 5e-11 \
    73.760001 0 73.8 0 73.800001 5e-11 73.81 5e-11 \
    73.810001 0 73.85 0 73.850001 5e-11 73.86 5e-11 \
    73.860001 0 73.9 0 73.900001 5e-11 73.91 5e-11 \
    73.910001 0 73.95 0 73.950001 5e-11 73.96 5e-11 \
    73.960001 0 74 0 74.000001 5e-11 74.01 5e-11 \
    74.010001 0 74.05 0 74.050001 5e-11 74.06 5e-11 \
    74.060001 0 74.1 0 74.100001 5e-11 74.11 5e-11 \
    74.110001 0 74.15 0 74.150001 5e-11 74.16 5e-11 \
    74.160001 0 74.2 0 74.200001 5e-11 74.21 5e-11 \
    74.210001 0 74.25 0 74.250001 5e-11 74.26 5e-11 \
    74.260001 0 74.3 0 74.300001 5e-11 74.31 5e-11 \
    74.310001 0 74.35 0 74.350001 5e-11 74.36 5e-11 \
    74.360001 0 74.4 0 74.400001 5e-11 74.41 5e-11 \
    74.410001 0 74.45 0 74.450001 5e-11 74.46 5e-11 \
    74.460001 0 74.5 0 74.500001 5e-11 74.51 5e-11 \
    74.510001 0 74.55 0 74.550001 5e-11 74.56 5e-11 \
    74.560001 0 74.6 0 74.600001 5e-11 74.61 5e-11 \
    74.610001 0 74.65 0 74.650001 5e-11 74.66 5e-11 \
    74.660001 0 74.7 0 74.700001 5e-11 74.71 5e-11 \
    74.710001 0 74.75 0 74.750001 5e-11 74.76 5e-11 \
    74.760001 0 74.8 0 74.800001 5e-11 74.81 5e-11 \
    74.810001 0 74.85 0 74.850001 5e-11 74.86 5e-11 \
    74.860001 0 74.9 0 74.900001 5e-11 74.91 5e-11 \
    74.910001 0 74.95 0 74.950001 5e-11 74.96 5e-11 \
    74.960001 0 75 0 75.000001 5e-11 75.01 5e-11 \
    75.010001 0 75.05 0 75.050001 5e-11 75.06 5e-11 \
    75.060001 0 75.1 0 75.100001 5e-11 75.11 5e-11 \
    75.110001 0 75.15 0 75.150001 5e-11 75.16 5e-11 \
    75.160001 0 75.2 0 75.200001 5e-11 75.21 5e-11 \
    75.210001 0 75.25 0 75.250001 5e-11 75.26 5e-11 \
    75.260001 0 75.3 0 75.300001 5e-11 75.31 5e-11 \
    75.310001 0 75.35 0 75.350001 5e-11 75.36 5e-11 \
    75.360001 0 75.4 0 75.400001 5e-11 75.41 5e-11 \
    75.410001 0 75.45 0 75.450001 5e-11 75.46 5e-11 \
    75.460001 0 75.5 0 75.500001 5e-11 75.51 5e-11 \
    75.510001 0 75.55 0 75.550001 5e-11 75.56 5e-11 \
    75.560001 0 75.6 0 75.600001 5e-11 75.61 5e-11 \
    75.610001 0 75.65 0 75.650001 5e-11 75.66 5e-11 \
    75.660001 0 75.7 0 75.700001 5e-11 75.71 5e-11 \
    75.710001 0 75.75 0 75.750001 5e-11 75.76 5e-11 \
    75.760001 0 75.8 0 75.800001 5e-11 75.81 5e-11 \
    75.810001 0 75.85 0 75.850001 5e-11 75.86 5e-11 \
    75.860001 0 75.9 0 75.900001 5e-11 75.91 5e-11 \
    75.910001 0 75.95 0 75.950001 5e-11 75.96 5e-11 \
    75.960001 0 76 0 76.000001 5e-11 76.01 5e-11 \
    76.010001 0 76.05 0 76.050001 5e-11 76.06 5e-11 \
    76.060001 0 76.1 0 76.100001 5e-11 76.11 5e-11 \
    76.110001 0 76.15 0 76.150001 5e-11 76.16 5e-11 \
    76.160001 0 76.2 0 76.200001 5e-11 76.21 5e-11 \
    76.210001 0 76.25 0 76.250001 5e-11 76.26 5e-11 \
    76.260001 0 76.3 0 76.300001 5e-11 76.31 5e-11 \
    76.310001 0 76.35 0 76.350001 5e-11 76.36 5e-11 \
    76.360001 0 76.4 0 76.400001 5e-11 76.41 5e-11 \
    76.410001 0 76.45 0 76.450001 5e-11 76.46 5e-11 \
    76.460001 0 76.5 0 76.500001 5e-11 76.51 5e-11 \
    76.510001 0 76.55 0 76.550001 5e-11 76.56 5e-11 \
    76.560001 0 76.6 0 76.600001 5e-11 76.61 5e-11 \
    76.610001 0 76.65 0 76.650001 5e-11 76.66 5e-11 \
    76.660001 0 76.7 0 76.700001 5e-11 76.71 5e-11 \
    76.710001 0 76.75 0 76.750001 5e-11 76.76 5e-11 \
    76.760001 0 76.8 0 76.800001 5e-11 76.81 5e-11 \
    76.810001 0 76.85 0 76.850001 5e-11 76.86 5e-11 \
    76.860001 0 76.9 0 76.900001 5e-11 76.91 5e-11 \
    76.910001 0 76.95 0 76.950001 5e-11 76.96 5e-11 \
    76.960001 0 77 0 77.000001 5e-11 77.01 5e-11 \
    77.010001 0 77.05 0 77.050001 5e-11 77.06 5e-11 \
    77.060001 0 77.1 0 77.100001 5e-11 77.11 5e-11 \
    77.110001 0 77.15 0 77.150001 5e-11 77.16 5e-11 \
    77.160001 0 77.2 0 77.200001 5e-11 77.21 5e-11 \
    77.210001 0 77.25 0 77.250001 5e-11 77.26 5e-11 \
    77.260001 0 77.3 0 77.300001 5e-11 77.31 5e-11 \
    77.310001 0 77.35 0 77.350001 5e-11 77.36 5e-11 \
    77.360001 0 77.4 0 77.400001 5e-11 77.41 5e-11 \
    77.410001 0 77.45 0 77.450001 5e-11 77.46 5e-11 \
    77.460001 0 77.5 0 77.500001 5e-11 77.51 5e-11 \
    77.510001 0 77.55 0 77.550001 5e-11 77.56 5e-11 \
    77.560001 0 77.6 0 77.600001 5e-11 77.61 5e-11 \
    77.610001 0 77.65 0 77.650001 5e-11 77.66 5e-11 \
    77.660001 0 77.7 0 77.700001 5e-11 77.71 5e-11 \
    77.710001 0 77.75 0 77.750001 5e-11 77.76 5e-11 \
    77.760001 0 77.8 0 77.800001 5e-11 77.81 5e-11 \
    77.810001 0 77.85 0 77.850001 5e-11 77.86 5e-11 \
    77.860001 0 77.9 0 77.900001 5e-11 77.91 5e-11 \
    77.910001 0 77.95 0 77.950001 5e-11 77.96 5e-11 \
    77.960001 0 78 0 78.000001 5e-11 78.01 5e-11 \
    78.010001 0 78.05 0 78.050001 5e-11 78.06 5e-11 \
    78.060001 0 78.1 0 78.100001 5e-11 78.11 5e-11 \
    78.110001 0 78.15 0 78.150001 5e-11 78.16 5e-11 \
    78.160001 0 78.2 0 78.200001 5e-11 78.21 5e-11 \
    78.210001 0 78.25 0 78.250001 5e-11 78.26 5e-11 \
    78.260001 0 78.3 0 78.300001 5e-11 78.31 5e-11 \
    78.310001 0 78.35 0 78.350001 5e-11 78.36 5e-11 \
    78.360001 0 78.4 0 78.400001 5e-11 78.41 5e-11 \
    78.410001 0 78.45 0 78.450001 5e-11 78.46 5e-11 \
    78.460001 0 78.5 0 78.500001 5e-11 78.51 5e-11 \
    78.510001 0 78.55 0 78.550001 5e-11 78.56 5e-11 \
    78.560001 0 78.6 0 78.600001 5e-11 78.61 5e-11 \
    78.610001 0 78.65 0 78.650001 5e-11 78.66 5e-11 \
    78.660001 0 78.7 0 78.700001 5e-11 78.71 5e-11 \
    78.710001 0 78.75 0 78.750001 5e-11 78.76 5e-11 \
    78.760001 0 78.8 0 78.800001 5e-11 78.81 5e-11 \
    78.810001 0 78.85 0 78.850001 5e-11 78.86 5e-11 \
    78.860001 0 78.9 0 78.900001 5e-11 78.91 5e-11 \
    78.910001 0 78.95 0 78.950001 5e-11 78.96 5e-11 \
    78.960001 0 79 0 79.000001 5e-11 79.01 5e-11 \
    79.010001 0 79.05 0 79.050001 5e-11 79.06 5e-11 \
    79.060001 0 79.1 0 79.100001 5e-11 79.11 5e-11 \
    79.110001 0 79.15 0 79.150001 5e-11 79.16 5e-11 \
    79.160001 0 79.2 0 79.200001 5e-11 79.21 5e-11 \
    79.210001 0 79.25 0 79.250001 5e-11 79.26 5e-11 \
    79.260001 0 79.3 0 79.300001 5e-11 79.31 5e-11 \
    79.310001 0 79.35 0 79.350001 5e-11 79.36 5e-11 \
    79.360001 0 79.4 0 79.400001 5e-11 79.41 5e-11 \
    79.410001 0 79.45 0 79.450001 5e-11 79.46 5e-11 \
    79.460001 0 79.5 0 79.500001 5e-11 79.51 5e-11 \
    79.510001 0 79.55 0 79.550001 5e-11 79.56 5e-11 \
    79.560001 0 79.6 0 79.600001 5e-11 79.61 5e-11 \
    79.610001 0 79.65 0 79.650001 5e-11 79.66 5e-11 \
    79.660001 0 79.7 0 79.700001 5e-11 79.71 5e-11 \
    79.710001 0 79.75 0 79.750001 5e-11 79.76 5e-11 \
    79.760001 0 79.8 0 79.800001 5e-11 79.81 5e-11 \
    79.810001 0 79.85 0 79.850001 5e-11 79.86 5e-11 \
    79.860001 0 79.9 0 79.900001 5e-11 79.91 5e-11 \
    79.910001 0 79.95 0 79.950001 5e-11 79.96 5e-11 \
    79.960001 0 80 0 80.000001 5e-11 80.01 5e-11 \
    80.010001 0 80.05 0 80.050001 5e-11 80.06 5e-11 \
    80.060001 0 80.1 0 80.100001 5e-11 80.11 5e-11 \
    80.110001 0 80.15 0 80.150001 5e-11 80.16 5e-11 \
    80.160001 0 80.2 0 80.200001 5e-11 80.21 5e-11 \
    80.210001 0 80.25 0 80.250001 5e-11 80.26 5e-11 \
    80.260001 0 80.3 0 80.300001 5e-11 80.31 5e-11 \
    80.310001 0 80.35 0 80.350001 5e-11 80.36 5e-11 \
    80.360001 0 80.4 0 80.400001 5e-11 80.41 5e-11 \
    80.410001 0 80.45 0 80.450001 5e-11 80.46 5e-11 \
    80.460001 0 80.5 0 80.500001 5e-11 80.51 5e-11 \
    80.510001 0 80.55 0 80.550001 5e-11 80.56 5e-11 \
    80.560001 0 80.6 0 80.600001 5e-11 80.61 5e-11 \
    80.610001 0 80.65 0 80.650001 5e-11 80.66 5e-11 \
    80.660001 0 80.7 0 80.700001 5e-11 80.71 5e-11 \
    80.710001 0 80.75 0 80.750001 5e-11 80.76 5e-11 \
    80.760001 0 80.8 0 80.800001 5e-11 80.81 5e-11 \
    80.810001 0 80.85 0 80.850001 5e-11 80.86 5e-11 \
    80.860001 0 80.9 0 80.900001 5e-11 80.91 5e-11 \
    80.910001 0 80.95 0 80.950001 5e-11 80.96 5e-11 \
    80.960001 0 81 0 81.000001 5e-11 81.01 5e-11 \
    81.010001 0 81.05 0 81.050001 5e-11 81.06 5e-11 \
    81.060001 0 81.1 0 81.100001 5e-11 81.11 5e-11 \
    81.110001 0 81.15 0 81.150001 5e-11 81.16 5e-11 \
    81.160001 0 81.2 0 81.200001 5e-11 81.21 5e-11 \
    81.210001 0 81.25 0 81.250001 5e-11 81.26 5e-11 \
    81.260001 0 81.3 0 81.300001 5e-11 81.31 5e-11 \
    81.310001 0 81.35 0 81.350001 5e-11 81.36 5e-11 \
    81.360001 0 81.4 0 81.400001 5e-11 81.41 5e-11 \
    81.410001 0 81.45 0 81.450001 5e-11 81.46 5e-11 \
    81.460001 0 81.5 0 81.500001 5e-11 81.51 5e-11 \
    81.510001 0 81.55 0 81.550001 5e-11 81.56 5e-11 \
    81.560001 0 81.6 0 81.600001 5e-11 81.61 5e-11 \
    81.610001 0 81.65 0 81.650001 5e-11 81.66 5e-11 \
    81.660001 0 81.7 0 81.700001 5e-11 81.71 5e-11 \
    81.710001 0 81.75 0 81.750001 5e-11 81.76 5e-11 \
    81.760001 0 81.8 0 81.800001 5e-11 81.81 5e-11 \
    81.810001 0 81.85 0 81.850001 5e-11 81.86 5e-11 \
    81.860001 0 81.9 0 81.900001 5e-11 81.91 5e-11 \
    81.910001 0 81.95 0 81.950001 5e-11 81.96 5e-11 \
    81.960001 0 82 0 82.000001 5e-11 82.01 5e-11 \
    82.010001 0 82.05 0 82.050001 5e-11 82.06 5e-11 \
    82.060001 0 82.1 0 82.100001 5e-11 82.11 5e-11 \
    82.110001 0 82.15 0 82.150001 5e-11 82.16 5e-11 \
    82.160001 0 82.2 0 82.200001 5e-11 82.21 5e-11 \
    82.210001 0 82.25 0 82.250001 5e-11 82.26 5e-11 \
    82.260001 0 82.3 0 82.300001 5e-11 82.31 5e-11 \
    82.310001 0 82.35 0 82.350001 5e-11 82.36 5e-11 \
    82.360001 0 82.4 0 82.400001 5e-11 82.41 5e-11 \
    82.410001 0 82.45 0 82.450001 5e-11 82.46 5e-11 \
    82.460001 0 82.5 0 82.500001 5e-11 82.51 5e-11 \
    82.510001 0 82.55 0 82.550001 5e-11 82.56 5e-11 \
    82.560001 0 82.6 0 82.600001 5e-11 82.61 5e-11 \
    82.610001 0 82.65 0 82.650001 5e-11 82.66 5e-11 \
    82.660001 0 82.7 0 82.700001 5e-11 82.71 5e-11 \
    82.710001 0 82.75 0 82.750001 5e-11 82.76 5e-11 \
    82.760001 0 82.8 0 82.800001 5e-11 82.81 5e-11 \
    82.810001 0 82.85 0 82.850001 5e-11 82.86 5e-11 \
    82.860001 0 82.9 0 82.900001 5e-11 82.91 5e-11 \
    82.910001 0 82.95 0 82.950001 5e-11 82.96 5e-11 \
    82.960001 0 83 0 83.000001 5e-11 83.01 5e-11 \
    83.010001 0 83.05 0 83.050001 5e-11 83.06 5e-11 \
    83.060001 0 83.1 0 83.100001 5e-11 83.11 5e-11 \
    83.110001 0 83.15 0 83.150001 5e-11 83.16 5e-11 \
    83.160001 0 83.2 0 83.200001 5e-11 83.21 5e-11 \
    83.210001 0 83.25 0 83.250001 5e-11 83.26 5e-11 \
    83.260001 0 83.3 0 83.300001 5e-11 83.31 5e-11 \
    83.310001 0 83.35 0 83.350001 5e-11 83.36 5e-11 \
    83.360001 0 83.4 0 83.400001 5e-11 83.41 5e-11 \
    83.410001 0 83.45 0 83.450001 5e-11 83.46 5e-11 \
    83.460001 0 83.5 0 83.500001 5e-11 83.51 5e-11 \
    83.510001 0 83.55 0 83.550001 5e-11 83.56 5e-11 \
    83.560001 0 83.6 0 83.600001 5e-11 83.61 5e-11 \
    83.610001 0 83.65 0 83.650001 5e-11 83.66 5e-11 \
    83.660001 0 83.7 0 83.700001 5e-11 83.71 5e-11 \
    83.710001 0 83.75 0 83.750001 5e-11 83.76 5e-11 \
    83.760001 0 83.8 0 83.800001 5e-11 83.81 5e-11 \
    83.810001 0 83.85 0 83.850001 5e-11 83.86 5e-11 \
    83.860001 0 83.9 0 83.900001 5e-11 83.91 5e-11 \
    83.910001 0 83.95 0 83.950001 5e-11 83.96 5e-11 \
    83.960001 0 84 0 84.000001 5e-11 84.01 5e-11 \
    84.010001 0 84.05 0 84.050001 5e-11 84.06 5e-11 \
    84.060001 0 84.1 0 84.100001 5e-11 84.11 5e-11 \
    84.110001 0 84.15 0 84.150001 5e-11 84.16 5e-11 \
    84.160001 0 84.2 0 84.200001 5e-11 84.21 5e-11 \
    84.210001 0 84.25 0 84.250001 5e-11 84.26 5e-11 \
    84.260001 0 84.3 0 84.300001 5e-11 84.31 5e-11 \
    84.310001 0 84.35 0 84.350001 5e-11 84.36 5e-11 \
    84.360001 0 84.4 0 84.400001 5e-11 84.41 5e-11 \
    84.410001 0 84.45 0 84.450001 5e-11 84.46 5e-11 \
    84.460001 0 84.5 0 84.500001 5e-11 84.51 5e-11 \
    84.510001 0 84.55 0 84.550001 5e-11 84.56 5e-11 \
    84.560001 0 84.6 0 84.600001 5e-11 84.61 5e-11 \
    84.610001 0 84.65 0 84.650001 5e-11 84.66 5e-11 \
    84.660001 0 84.7 0 84.700001 5e-11 84.71 5e-11 \
    84.710001 0 84.75 0 84.750001 5e-11 84.76 5e-11 \
    84.760001 0 84.8 0 84.800001 5e-11 84.81 5e-11 \
    84.810001 0 84.85 0 84.850001 5e-11 84.86 5e-11 \
    84.860001 0 84.9 0 84.900001 5e-11 84.91 5e-11 \
    84.910001 0 84.95 0 84.950001 5e-11 84.96 5e-11 \
    84.960001 0 85 0 85.000001 5e-11 85.01 5e-11 \
    85.010001 0 85.05 0 85.050001 5e-11 85.06 5e-11 \
    85.060001 0 85.1 0 85.100001 5e-11 85.11 5e-11 \
    85.110001 0 85.15 0 85.150001 5e-11 85.16 5e-11 \
    85.160001 0 85.2 0 85.200001 5e-11 85.21 5e-11 \
    85.210001 0 85.25 0 85.250001 5e-11 85.26 5e-11 \
    85.260001 0 85.3 0 85.300001 5e-11 85.31 5e-11 \
    85.310001 0 85.35 0 85.350001 5e-11 85.36 5e-11 \
    85.360001 0 85.4 0 85.400001 5e-11 85.41 5e-11 \
    85.410001 0 85.45 0 85.450001 5e-11 85.46 5e-11 \
    85.460001 0 85.5 0 85.500001 5e-11 85.51 5e-11 \
    85.510001 0 85.55 0 85.550001 5e-11 85.56 5e-11 \
    85.560001 0 85.6 0 85.600001 5e-11 85.61 5e-11 \
    85.610001 0 85.65 0 85.650001 5e-11 85.66 5e-11 \
    85.660001 0 85.7 0 85.700001 5e-11 85.71 5e-11 \
    85.710001 0 85.75 0 85.750001 5e-11 85.76 5e-11 \
    85.760001 0 85.8 0 85.800001 5e-11 85.81 5e-11 \
    85.810001 0 85.85 0 85.850001 5e-11 85.86 5e-11 \
    85.860001 0 85.9 0 85.900001 5e-11 85.91 5e-11 \
    85.910001 0 85.95 0 85.950001 5e-11 85.96 5e-11 \
    85.960001 0 86 0 86.000001 5e-11 86.01 5e-11 \
    86.010001 0 86.05 0 86.050001 5e-11 86.06 5e-11 \
    86.060001 0 86.1 0 86.100001 5e-11 86.11 5e-11 \
    86.110001 0 86.15 0 86.150001 5e-11 86.16 5e-11 \
    86.160001 0 86.2 0 86.200001 5e-11 86.21 5e-11 \
    86.210001 0 86.25 0 86.250001 5e-11 86.26 5e-11 \
    86.260001 0 86.3 0 86.300001 5e-11 86.31 5e-11 \
    86.310001 0 86.35 0 86.350001 5e-11 86.36 5e-11 \
    86.360001 0 86.4 0 86.400001 5e-11 86.41 5e-11 \
    86.410001 0 86.45 0 86.450001 5e-11 86.46 5e-11 \
    86.460001 0 86.5 0 86.500001 5e-11 86.51 5e-11 \
    86.510001 0 86.55 0 86.550001 5e-11 86.56 5e-11 \
    86.560001 0 86.6 0 86.600001 5e-11 86.61 5e-11 \
    86.610001 0 86.65 0 86.650001 5e-11 86.66 5e-11 \
    86.660001 0 86.7 0 86.700001 5e-11 86.71 5e-11 \
    86.710001 0 86.75 0 86.750001 5e-11 86.76 5e-11 \
    86.760001 0 86.8 0 86.800001 5e-11 86.81 5e-11 \
    86.810001 0 86.85 0 86.850001 5e-11 86.86 5e-11 \
    86.860001 0 86.9 0 86.900001 5e-11 86.91 5e-11 \
    86.910001 0 86.95 0 86.950001 5e-11 86.96 5e-11 \
    86.960001 0 87 0 87.000001 5e-11 87.01 5e-11 \
    87.010001 0 87.05 0 87.050001 5e-11 87.06 5e-11 \
    87.060001 0 87.1 0 87.100001 5e-11 87.11 5e-11 \
    87.110001 0 87.15 0 87.150001 5e-11 87.16 5e-11 \
    87.160001 0 87.2 0 87.200001 5e-11 87.21 5e-11 \
    87.210001 0 87.25 0 87.250001 5e-11 87.26 5e-11 \
    87.260001 0 87.3 0 87.300001 5e-11 87.31 5e-11 \
    87.310001 0 87.35 0 87.350001 5e-11 87.36 5e-11 \
    87.360001 0 87.4 0 87.400001 5e-11 87.41 5e-11 \
    87.410001 0 87.45 0 87.450001 5e-11 87.46 5e-11 \
    87.460001 0 87.5 0 87.500001 5e-11 87.51 5e-11 \
    87.510001 0 87.55 0 87.550001 5e-11 87.56 5e-11 \
    87.560001 0 87.6 0 87.600001 5e-11 87.61 5e-11 \
    87.610001 0 87.65 0 87.650001 5e-11 87.66 5e-11 \
    87.660001 0 87.7 0 87.700001 5e-11 87.71 5e-11 \
    87.710001 0 87.75 0 87.750001 5e-11 87.76 5e-11 \
    87.760001 0 87.8 0 87.800001 5e-11 87.81 5e-11 \
    87.810001 0 87.85 0 87.850001 5e-11 87.86 5e-11 \
    87.860001 0 87.9 0 87.900001 5e-11 87.91 5e-11 \
    87.910001 0 87.95 0 87.950001 5e-11 87.96 5e-11 \
    87.960001 0 88 0 88.000001 5e-11 88.01 5e-11 \
    88.010001 0 88.05 0 88.050001 5e-11 88.06 5e-11 \
    88.060001 0 88.1 0 88.100001 5e-11 88.11 5e-11 \
    88.110001 0 88.15 0 88.150001 5e-11 88.16 5e-11 \
    88.160001 0 88.2 0 88.200001 5e-11 88.21 5e-11 \
    88.210001 0 88.25 0 88.250001 5e-11 88.26 5e-11 \
    88.260001 0 88.3 0 88.300001 5e-11 88.31 5e-11 \
    88.310001 0 88.35 0 88.350001 5e-11 88.36 5e-11 \
    88.360001 0 88.4 0 88.400001 5e-11 88.41 5e-11 \
    88.410001 0 88.45 0 88.450001 5e-11 88.46 5e-11 \
    88.460001 0 88.5 0 88.500001 5e-11 88.51 5e-11 \
    88.510001 0 88.55 0 88.550001 5e-11 88.56 5e-11 \
    88.560001 0 88.6 0 88.600001 5e-11 88.61 5e-11 \
    88.610001 0 88.65 0 88.650001 5e-11 88.66 5e-11 \
    88.660001 0 88.7 0 88.700001 5e-11 88.71 5e-11 \
    88.710001 0 88.75 0 88.750001 5e-11 88.76 5e-11 \
    88.760001 0 88.8 0 88.800001 5e-11 88.81 5e-11 \
    88.810001 0 88.85 0 88.850001 5e-11 88.86 5e-11 \
    88.860001 0 88.9 0 88.900001 5e-11 88.91 5e-11 \
    88.910001 0 88.95 0 88.950001 5e-11 88.96 5e-11 \
    88.960001 0 89 0 89.000001 5e-11 89.01 5e-11 \
    89.010001 0 89.05 0 89.050001 5e-11 89.06 5e-11 \
    89.060001 0 89.1 0 89.100001 5e-11 89.11 5e-11 \
    89.110001 0 89.15 0 89.150001 5e-11 89.16 5e-11 \
    89.160001 0 89.2 0 89.200001 5e-11 89.21 5e-11 \
    89.210001 0 89.25 0 89.250001 5e-11 89.26 5e-11 \
    89.260001 0 89.3 0 89.300001 5e-11 89.31 5e-11 \
    89.310001 0 89.35 0 89.350001 5e-11 89.36 5e-11 \
    89.360001 0 89.4 0 89.400001 5e-11 89.41 5e-11 \
    89.410001 0 89.45 0 89.450001 5e-11 89.46 5e-11 \
    89.460001 0 89.5 0 89.500001 5e-11 89.51 5e-11 \
    89.510001 0 89.55 0 89.550001 5e-11 89.56 5e-11 \
    89.560001 0 89.6 0 89.600001 5e-11 89.61 5e-11 \
    89.610001 0 89.65 0 89.650001 5e-11 89.66 5e-11 \
    89.660001 0 89.7 0 89.700001 5e-11 89.71 5e-11 \
    89.710001 0 89.75 0 89.750001 5e-11 89.76 5e-11 \
    89.760001 0 89.8 0 89.800001 5e-11 89.81 5e-11 \
    89.810001 0 89.85 0 89.850001 5e-11 89.86 5e-11 \
    89.860001 0 89.9 0 89.900001 5e-11 89.91 5e-11 \
    89.910001 0 89.95 0 89.950001 5e-11 89.96 5e-11 \
    89.960001 0 90 0 90.000001 5e-11 90.01 5e-11 \
    90.010001 0 90.05 0 90.050001 5e-11 90.06 5e-11 \
    90.060001 0 90.1 0 90.100001 5e-11 90.11 5e-11 \
    90.110001 0 90.15 0 90.150001 5e-11 90.16 5e-11 \
    90.160001 0 90.2 0 90.200001 5e-11 90.21 5e-11 \
    90.210001 0 90.25 0 90.250001 5e-11 90.26 5e-11 \
    90.260001 0 90.3 0 90.300001 5e-11 90.31 5e-11 \
    90.310001 0 90.35 0 90.350001 5e-11 90.36 5e-11 \
    90.360001 0 90.4 0 90.400001 5e-11 90.41 5e-11 \
    90.410001 0 90.45 0 90.450001 5e-11 90.46 5e-11 \
    90.460001 0 90.5 0 90.500001 5e-11 90.51 5e-11 \
    90.510001 0 90.55 0 90.550001 5e-11 90.56 5e-11 \
    90.560001 0 90.6 0 90.600001 5e-11 90.61 5e-11 \
    90.610001 0 90.65 0 90.650001 5e-11 90.66 5e-11 \
    90.660001 0 90.7 0 90.700001 5e-11 90.71 5e-11 \
    90.710001 0 90.75 0 90.750001 5e-11 90.76 5e-11 \
    90.760001 0 90.8 0 90.800001 5e-11 90.81 5e-11 \
    90.810001 0 90.85 0 90.850001 5e-11 90.86 5e-11 \
    90.860001 0 90.9 0 90.900001 5e-11 90.91 5e-11 \
    90.910001 0 90.95 0 90.950001 5e-11 90.96 5e-11 \
    90.960001 0 91 0 91.000001 5e-11 91.01 5e-11 \
    91.010001 0 91.05 0 91.050001 5e-11 91.06 5e-11 \
    91.060001 0 91.1 0 91.100001 5e-11 91.11 5e-11 \
    91.110001 0 91.15 0 91.150001 5e-11 91.16 5e-11 \
    91.160001 0 91.2 0 91.200001 5e-11 91.21 5e-11 \
    91.210001 0 91.25 0 91.250001 5e-11 91.26 5e-11 \
    91.260001 0 91.3 0 91.300001 5e-11 91.31 5e-11 \
    91.310001 0 91.35 0 91.350001 5e-11 91.36 5e-11 \
    91.360001 0 91.4 0 91.400001 5e-11 91.41 5e-11 \
    91.410001 0 91.45 0 91.450001 5e-11 91.46 5e-11 \
    91.460001 0 91.5 0 91.500001 5e-11 91.51 5e-11 \
    91.510001 0 91.55 0 91.550001 5e-11 91.56 5e-11 \
    91.560001 0 91.6 0 91.600001 5e-11 91.61 5e-11 \
    91.610001 0 91.65 0 91.650001 5e-11 91.66 5e-11 \
    91.660001 0 91.7 0 91.700001 5e-11 91.71 5e-11 \
    91.710001 0 91.75 0 91.750001 5e-11 91.76 5e-11 \
    91.760001 0 91.8 0 91.800001 5e-11 91.81 5e-11 \
    91.810001 0 91.85 0 91.850001 5e-11 91.86 5e-11 \
    91.860001 0 91.9 0 91.900001 5e-11 91.91 5e-11 \
    91.910001 0 91.95 0 91.950001 5e-11 91.96 5e-11 \
    91.960001 0 92 0 92.000001 5e-11 92.01 5e-11 \
    92.010001 0 92.05 0 92.050001 5e-11 92.06 5e-11 \
    92.060001 0 92.1 0 92.100001 5e-11 92.11 5e-11 \
    92.110001 0 92.15 0 92.150001 5e-11 92.16 5e-11 \
    92.160001 0 92.2 0 92.200001 5e-11 92.21 5e-11 \
    92.210001 0 92.25 0 92.250001 5e-11 92.26 5e-11 \
    92.260001 0 92.3 0 92.300001 5e-11 92.31 5e-11 \
    92.310001 0 92.35 0 92.350001 5e-11 92.36 5e-11 \
    92.360001 0 92.4 0 92.400001 5e-11 92.41 5e-11 \
    92.410001 0 92.45 0 92.450001 5e-11 92.46 5e-11 \
    92.460001 0 92.5 0 92.500001 5e-11 92.51 5e-11 \
    92.510001 0 92.55 0 92.550001 5e-11 92.56 5e-11 \
    92.560001 0 92.6 0 92.600001 5e-11 92.61 5e-11 \
    92.610001 0 92.65 0 92.650001 5e-11 92.66 5e-11 \
    92.660001 0 92.7 0 92.700001 5e-11 92.71 5e-11 \
    92.710001 0 92.75 0 92.750001 5e-11 92.76 5e-11 \
    92.760001 0 92.8 0 92.800001 5e-11 92.81 5e-11 \
    92.810001 0 92.85 0 92.850001 5e-11 92.86 5e-11 \
    92.860001 0 92.9 0 92.900001 5e-11 92.91 5e-11 \
    92.910001 0 92.95 0 92.950001 5e-11 92.96 5e-11 \
    92.960001 0 93 0 93.000001 5e-11 93.01 5e-11 \
    93.010001 0 93.05 0 93.050001 5e-11 93.06 5e-11 \
    93.060001 0 93.1 0 93.100001 5e-11 93.11 5e-11 \
    93.110001 0 93.15 0 93.150001 5e-11 93.16 5e-11 \
    93.160001 0 93.2 0 93.200001 5e-11 93.21 5e-11 \
    93.210001 0 93.25 0 93.250001 5e-11 93.26 5e-11 \
    93.260001 0 93.3 0 93.300001 5e-11 93.31 5e-11 \
    93.310001 0 93.35 0 93.350001 5e-11 93.36 5e-11 \
    93.360001 0 93.4 0 93.400001 5e-11 93.41 5e-11 \
    93.410001 0 93.45 0 93.450001 5e-11 93.46 5e-11 \
    93.460001 0 93.5 0 93.500001 5e-11 93.51 5e-11 \
    93.510001 0 93.55 0 93.550001 5e-11 93.56 5e-11 \
    93.560001 0 93.6 0 93.600001 5e-11 93.61 5e-11 \
    93.610001 0 93.65 0 93.650001 5e-11 93.66 5e-11 \
    93.660001 0 93.7 0 93.700001 5e-11 93.71 5e-11 \
    93.710001 0 93.75 0 93.750001 5e-11 93.76 5e-11 \
    93.760001 0 93.8 0 93.800001 5e-11 93.81 5e-11 \
    93.810001 0 93.85 0 93.850001 5e-11 93.86 5e-11 \
    93.860001 0 93.9 0 93.900001 5e-11 93.91 5e-11 \
    93.910001 0 93.95 0 93.950001 5e-11 93.96 5e-11 \
    93.960001 0 94 0 94.000001 5e-11 94.01 5e-11 \
    94.010001 0 94.05 0 94.050001 5e-11 94.06 5e-11 \
    94.060001 0 94.1 0 94.100001 5e-11 94.11 5e-11 \
    94.110001 0 94.15 0 94.150001 5e-11 94.16 5e-11 \
    94.160001 0 94.2 0 94.200001 5e-11 94.21 5e-11 \
    94.210001 0 94.25 0 94.250001 5e-11 94.26 5e-11 \
    94.260001 0 94.3 0 94.300001 5e-11 94.31 5e-11 \
    94.310001 0 94.35 0 94.350001 5e-11 94.36 5e-11 \
    94.360001 0 94.4 0 94.400001 5e-11 94.41 5e-11 \
    94.410001 0 94.45 0 94.450001 5e-11 94.46 5e-11 \
    94.460001 0 94.5 0 94.500001 5e-11 94.51 5e-11 \
    94.510001 0 94.55 0 94.550001 5e-11 94.56 5e-11 \
    94.560001 0 94.6 0 94.600001 5e-11 94.61 5e-11 \
    94.610001 0 94.65 0 94.650001 5e-11 94.66 5e-11 \
    94.660001 0 94.7 0 94.700001 5e-11 94.71 5e-11 \
    94.710001 0 94.75 0 94.750001 5e-11 94.76 5e-11 \
    94.760001 0 94.8 0 94.800001 5e-11 94.81 5e-11 \
    94.810001 0 94.85 0 94.850001 5e-11 94.86 5e-11 \
    94.860001 0 94.9 0 94.900001 5e-11 94.91 5e-11 \
    94.910001 0 94.95 0 94.950001 5e-11 94.96 5e-11 \
    94.960001 0 95 0 95.000001 5e-11 95.01 5e-11 \
    95.010001 0 95.05 0 95.050001 5e-11 95.06 5e-11 \
    95.060001 0 95.1 0 95.100001 5e-11 95.11 5e-11 \
    95.110001 0 95.15 0 95.150001 5e-11 95.16 5e-11 \
    95.160001 0 95.2 0 95.200001 5e-11 95.21 5e-11 \
    95.210001 0 95.25 0 95.250001 5e-11 95.26 5e-11 \
    95.260001 0 95.3 0 95.300001 5e-11 95.31 5e-11 \
    95.310001 0 95.35 0 95.350001 5e-11 95.36 5e-11 \
    95.360001 0 95.4 0 95.400001 5e-11 95.41 5e-11 \
    95.410001 0 95.45 0 95.450001 5e-11 95.46 5e-11 \
    95.460001 0 95.5 0 95.500001 5e-11 95.51 5e-11 \
    95.510001 0 95.55 0 95.550001 5e-11 95.56 5e-11 \
    95.560001 0 95.6 0 95.600001 5e-11 95.61 5e-11 \
    95.610001 0 95.65 0 95.650001 5e-11 95.66 5e-11 \
    95.660001 0 95.7 0 95.700001 5e-11 95.71 5e-11 \
    95.710001 0 95.75 0 95.750001 5e-11 95.76 5e-11 \
    95.760001 0 95.8 0 95.800001 5e-11 95.81 5e-11 \
    95.810001 0 95.85 0 95.850001 5e-11 95.86 5e-11 \
    95.860001 0 95.9 0 95.900001 5e-11 95.91 5e-11 \
    95.910001 0 95.95 0 95.950001 5e-11 95.96 5e-11 \
    95.960001 0 96 0 96.000001 5e-11 96.01 5e-11 \
    96.010001 0 96.05 0 96.050001 5e-11 96.06 5e-11 \
    96.060001 0 96.1 0 96.100001 5e-11 96.11 5e-11 \
    96.110001 0 96.15 0 96.150001 5e-11 96.16 5e-11 \
    96.160001 0 96.2 0 96.200001 5e-11 96.21 5e-11 \
    96.210001 0 96.25 0 96.250001 5e-11 96.26 5e-11 \
    96.260001 0 96.3 0 96.300001 5e-11 96.31 5e-11 \
    96.310001 0 96.35 0 96.350001 5e-11 96.36 5e-11 \
    96.360001 0 96.4 0 96.400001 5e-11 96.41 5e-11 \
    96.410001 0 96.45 0 96.450001 5e-11 96.46 5e-11 \
    96.460001 0 96.5 0 96.500001 5e-11 96.51 5e-11 \
    96.510001 0 96.55 0 96.550001 5e-11 96.56 5e-11 \
    96.560001 0 96.6 0 96.600001 5e-11 96.61 5e-11 \
    96.610001 0 96.65 0 96.650001 5e-11 96.66 5e-11 \
    96.660001 0 96.7 0 96.700001 5e-11 96.71 5e-11 \
    96.710001 0 96.75 0 96.750001 5e-11 96.76 5e-11 \
    96.760001 0 96.8 0 96.800001 5e-11 96.81 5e-11 \
    96.810001 0 96.85 0 96.850001 5e-11 96.86 5e-11 \
    96.860001 0 96.9 0 96.900001 5e-11 96.91 5e-11 \
    96.910001 0 96.95 0 96.950001 5e-11 96.96 5e-11 \
    96.960001 0 97 0 97.000001 5e-11 97.01 5e-11 \
    97.010001 0 97.05 0 97.050001 5e-11 97.06 5e-11 \
    97.060001 0 97.1 0 97.100001 5e-11 97.11 5e-11 \
    97.110001 0 97.15 0 97.150001 5e-11 97.16 5e-11 \
    97.160001 0 97.2 0 97.200001 5e-11 97.21 5e-11 \
    97.210001 0 97.25 0 97.250001 5e-11 97.26 5e-11 \
    97.260001 0 97.3 0 97.300001 5e-11 97.31 5e-11 \
    97.310001 0 97.35 0 97.350001 5e-11 97.36 5e-11 \
    97.360001 0 97.4 0 97.400001 5e-11 97.41 5e-11 \
    97.410001 0 97.45 0 97.450001 5e-11 97.46 5e-11 \
    97.460001 0 97.5 0 97.500001 5e-11 97.51 5e-11 \
    97.510001 0 97.55 0 97.550001 5e-11 97.56 5e-11 \
    97.560001 0 97.6 0 97.600001 5e-11 97.61 5e-11 \
    97.610001 0 97.65 0 97.650001 5e-11 97.66 5e-11 \
    97.660001 0 97.7 0 97.700001 5e-11 97.71 5e-11 \
    97.710001 0 97.75 0 97.750001 5e-11 97.76 5e-11 \
    97.760001 0 97.8 0 97.800001 5e-11 97.81 5e-11 \
    97.810001 0 97.85 0 97.850001 5e-11 97.86 5e-11 \
    97.860001 0 97.9 0 97.900001 5e-11 97.91 5e-11 \
    97.910001 0 97.95 0 97.950001 5e-11 97.96 5e-11 \
    97.960001 0 98 0 98.000001 5e-11 98.01 5e-11 \
    98.010001 0 98.05 0 98.050001 5e-11 98.06 5e-11 \
    98.060001 0 98.1 0 98.100001 5e-11 98.11 5e-11 \
    98.110001 0 98.15 0 98.150001 5e-11 98.16 5e-11 \
    98.160001 0 98.2 0 98.200001 5e-11 98.21 5e-11 \
    98.210001 0 98.25 0 98.250001 5e-11 98.26 5e-11 \
    98.260001 0 98.3 0 98.300001 5e-11 98.31 5e-11 \
    98.310001 0 98.35 0 98.350001 5e-11 98.36 5e-11 \
    98.360001 0 98.4 0 98.400001 5e-11 98.41 5e-11 \
    98.410001 0 98.45 0 98.450001 5e-11 98.46 5e-11 \
    98.460001 0 98.5 0 98.500001 5e-11 98.51 5e-11 \
    98.510001 0 98.55 0 98.550001 5e-11 98.56 5e-11 \
    98.560001 0 98.6 0 98.600001 5e-11 98.61 5e-11 \
    98.610001 0 98.65 0 98.650001 5e-11 98.66 5e-11 \
    98.660001 0 98.7 0 98.700001 5e-11 98.71 5e-11 \
    98.710001 0 98.75 0 98.750001 5e-11 98.76 5e-11 \
    98.760001 0 98.8 0 98.800001 5e-11 98.81 5e-11 \
    98.810001 0 98.85 0 98.850001 5e-11 98.86 5e-11 \
    98.860001 0 98.9 0 98.900001 5e-11 98.91 5e-11 \
    98.910001 0 98.95 0 98.950001 5e-11 98.96 5e-11 \
    98.960001 0 99 0 99.000001 5e-11 99.01 5e-11 \
    99.010001 0 99.05 0 99.050001 5e-11 99.06 5e-11 \
    99.060001 0 99.1 0 99.100001 5e-11 99.11 5e-11 \
    99.110001 0 99.15 0 99.150001 5e-11 99.16 5e-11 \
    99.160001 0 99.2 0 99.200001 5e-11 99.21 5e-11 \
    99.210001 0 99.25 0 99.250001 5e-11 99.26 5e-11 \
    99.260001 0 99.3 0 99.300001 5e-11 99.31 5e-11 \
    99.310001 0 99.35 0 99.350001 5e-11 99.36 5e-11 \
    99.360001 0 99.4 0 99.400001 5e-11 99.41 5e-11 \
    99.410001 0 99.45 0 99.450001 5e-11 99.46 5e-11 \
    99.460001 0 99.5 0 99.500001 5e-11 99.51 5e-11 \
    99.510001 0 99.55 0 99.550001 5e-11 99.56 5e-11 \
    99.560001 0 99.6 0 99.600001 5e-11 99.61 5e-11 \
    99.610001 0 99.65 0 99.650001 5e-11 99.66 5e-11 \
    99.660001 0 99.7 0 99.700001 5e-11 99.71 5e-11 \
    99.710001 0 99.75 0 99.750001 5e-11 99.76 5e-11 \
    99.760001 0 99.8 0 99.800001 5e-11 99.81 5e-11 \
    99.810001 0 99.85 0 99.850001 5e-11 99.86 5e-11 \
    99.860001 0 99.9 0 99.900001 5e-11 99.91 5e-11 \
    99.910001 0 99.95 0 99.950001 5e-11 99.96 5e-11 \
    99.960001 0 100 0 100.000001 5e-11 100.01 5e-11 \
    100.010001 0 100.05 0 100.050001 5e-11 100.06 5e-11 \
    100.060001 0 100.1 0 100.100001 5e-11 100.11 5e-11 \
    100.110001 0 100.15 0 100.150001 5e-11 100.16 5e-11 \
    100.160001 0 100.2 0 100.200001 5e-11 100.21 5e-11 \
    100.210001 0 100.25 0 100.250001 5e-11 100.26 5e-11 \
    100.260001 0 100.3 0 100.300001 5e-11 100.31 5e-11 \
    100.310001 0 100.35 0 100.350001 5e-11 100.36 5e-11 \
    100.360001 0 100.4 0 100.400001 5e-11 100.41 5e-11 \
    100.410001 0 100.45 0 100.450001 5e-11 100.46 5e-11 \
    100.460001 0 100.5 0 100.500001 5e-11 100.51 5e-11 \
    100.510001 0 100.55 0 100.550001 5e-11 100.56 5e-11 \
    100.560001 0 100.6 0 100.600001 5e-11 100.61 5e-11 \
    100.610001 0 100.65 0 100.650001 5e-11 100.66 5e-11 \
    100.660001 0 100.7 0 100.700001 5e-11 100.71 5e-11 \
    100.710001 0 100.75 0 100.750001 5e-11 100.76 5e-11 \
    100.760001 0 100.8 0 100.800001 5e-11 100.81 5e-11 \
    100.810001 0 100.85 0 100.850001 5e-11 100.86 5e-11 \
    100.860001 0 100.9 0 100.900001 5e-11 100.91 5e-11 \
    100.910001 0 100.95 0 100.950001 5e-11 100.96 5e-11 \
    100.960001 0 101 0 101.000001 5e-11 101.01 5e-11 \
    101.010001 0 101.05 0 101.050001 5e-11 101.06 5e-11 \
    101.060001 0 101.1 0 101.100001 5e-11 101.11 5e-11 \
    101.110001 0 101.15 0 101.150001 5e-11 101.16 5e-11 \
    101.160001 0 101.2 0 101.200001 5e-11 101.21 5e-11 \
    101.210001 0 101.25 0 101.250001 5e-11 101.26 5e-11 \
    101.260001 0 101.3 0 101.300001 5e-11 101.31 5e-11 \
    101.310001 0 101.35 0 101.350001 5e-11 101.36 5e-11 \
    101.360001 0 101.4 0 101.400001 5e-11 101.41 5e-11 \
    101.410001 0 101.45 0 101.450001 5e-11 101.46 5e-11 \
    101.460001 0 101.5 0 101.500001 5e-11 101.51 5e-11 \
    101.510001 0 101.55 0 101.550001 5e-11 101.56 5e-11 \
    101.560001 0 101.6 0 101.600001 5e-11 101.61 5e-11 \
    101.610001 0 101.65 0 101.650001 5e-11 101.66 5e-11 \
    101.660001 0 101.7 0 101.700001 5e-11 101.71 5e-11 \
    101.710001 0 101.75 0 101.750001 5e-11 101.76 5e-11 \
    101.760001 0 101.8 0 101.800001 5e-11 101.81 5e-11 \
    101.810001 0 101.85 0 101.850001 5e-11 101.86 5e-11 \
    101.860001 0 101.9 0 101.900001 5e-11 101.91 5e-11 \
    101.910001 0 101.95 0 101.950001 5e-11 101.96 5e-11 \
    101.960001 0 102 0 102.000001 5e-11 102.01 5e-11 \
    102.010001 0 102.05 0 102.050001 5e-11 102.06 5e-11 \
    102.060001 0 102.1 0 102.100001 5e-11 102.11 5e-11 \
    102.110001 0 102.15 0 102.150001 5e-11 102.16 5e-11 \
    102.160001 0 102.2 0 102.200001 5e-11 102.21 5e-11 \
    102.210001 0 102.25 0 102.250001 5e-11 102.26 5e-11 \
    102.260001 0 102.3 0 102.300001 5e-11 102.31 5e-11 \
    102.310001 0 102.35 0 102.350001 5e-11 102.36 5e-11 \
    102.360001 0 102.4 0 102.400001 5e-11 102.41 5e-11 \
    102.410001 0 102.45 0 102.450001 5e-11 102.46 5e-11 \
    102.460001 0 102.5 0 102.500001 5e-11 102.51 5e-11 \
    102.510001 0 102.55 0 102.550001 5e-11 102.56 5e-11 \
    102.560001 0 102.6 0 102.600001 5e-11 102.61 5e-11 \
    102.610001 0 102.65 0 102.650001 5e-11 102.66 5e-11 \
    102.660001 0 102.7 0 102.700001 5e-11 102.71 5e-11 \
    102.710001 0 102.75 0 102.750001 5e-11 102.76 5e-11 \
    102.760001 0 102.8 0 102.800001 5e-11 102.81 5e-11 \
    102.810001 0 102.85 0 102.850001 5e-11 102.86 5e-11 \
    102.860001 0 102.9 0 102.900001 5e-11 102.91 5e-11 \
    102.910001 0 102.95 0 102.950001 5e-11 102.96 5e-11 \
    102.960001 0 103 0 103.000001 5e-11 103.01 5e-11 \
    103.010001 0 103.05 0 103.050001 5e-11 103.06 5e-11 \
    103.060001 0 103.1 0 103.100001 5e-11 103.11 5e-11 \
    103.110001 0 103.15 0 103.150001 5e-11 103.16 5e-11 \
    103.160001 0 103.2 0 103.200001 5e-11 103.21 5e-11 \
    103.210001 0 103.25 0 103.250001 5e-11 103.26 5e-11 \
    103.260001 0 103.3 0 103.300001 5e-11 103.31 5e-11 \
    103.310001 0 103.35 0 103.350001 5e-11 103.36 5e-11 \
    103.360001 0 103.4 0 103.400001 5e-11 103.41 5e-11 \
    103.410001 0 103.45 0 103.450001 5e-11 103.46 5e-11 \
    103.460001 0 103.5 0 103.500001 5e-11 103.51 5e-11 \
    103.510001 0 103.55 0 103.550001 5e-11 103.56 5e-11 \
    103.560001 0 103.6 0 103.600001 5e-11 103.61 5e-11 \
    103.610001 0 103.65 0 103.650001 5e-11 103.66 5e-11 \
    103.660001 0 103.7 0 103.700001 5e-11 103.71 5e-11 \
    103.710001 0 103.75 0 103.750001 5e-11 103.76 5e-11 \
    103.760001 0 103.8 0 103.800001 5e-11 103.81 5e-11 \
    103.810001 0 103.85 0 103.850001 5e-11 103.86 5e-11 \
    103.860001 0 103.9 0 103.900001 5e-11 103.91 5e-11 \
    103.910001 0 103.95 0 103.950001 5e-11 103.96 5e-11 \
    103.960001 0 104 0 104.000001 5e-11 104.01 5e-11 \
    104.010001 0 104.05 0 104.050001 5e-11 104.06 5e-11 \
    104.060001 0 104.1 0 104.100001 5e-11 104.11 5e-11 \
    104.110001 0 104.15 0 104.150001 5e-11 104.16 5e-11 \
    104.160001 0 104.2 0 104.200001 5e-11 104.21 5e-11 \
    104.210001 0 104.25 0 104.250001 5e-11 104.26 5e-11 \
    104.260001 0 104.3 0 104.300001 5e-11 104.31 5e-11 \
    104.310001 0 104.35 0 104.350001 5e-11 104.36 5e-11 \
    104.360001 0 104.4 0 104.400001 5e-11 104.41 5e-11 \
    104.410001 0 104.45 0 104.450001 5e-11 104.46 5e-11 \
    104.460001 0 104.5 0 104.500001 5e-11 104.51 5e-11 \
    104.510001 0 104.55 0 104.550001 5e-11 104.56 5e-11 \
    104.560001 0 104.6 0 104.600001 5e-11 104.61 5e-11 \
    104.610001 0 104.65 0 104.650001 5e-11 104.66 5e-11 \
    104.660001 0 104.7 0 104.700001 5e-11 104.71 5e-11 \
    104.710001 0 104.75 0 104.750001 5e-11 104.76 5e-11 \
    104.760001 0 104.8 0 104.800001 5e-11 104.81 5e-11 \
    104.810001 0 104.85 0 104.850001 5e-11 104.86 5e-11 \
    104.860001 0 104.9 0 104.900001 5e-11 104.91 5e-11 \
    104.910001 0 104.95 0 104.950001 5e-11 104.96 5e-11 \
    104.960001 0 105 0 105.000001 5e-11 105.01 5e-11 \
    105.010001 0 105.05 0 105.050001 5e-11 105.06 5e-11 \
    105.060001 0 105.1 0 105.100001 -5e-11 105.11 -5e-11 \
    105.110001 0 105.15 0 105.150001 -5e-11 105.16 -5e-11 \
    105.160001 0 105.2 0 105.200001 -5e-11 105.21 -5e-11 \
    105.210001 0 105.25 0 105.250001 -5e-11 105.26 -5e-11 \
    105.260001 0 105.3 0 105.300001 -5e-11 105.31 -5e-11 \
    105.310001 0 105.35 0 105.350001 -5e-11 105.36 -5e-11 \
    105.360001 0 105.4 0 105.400001 -5e-11 105.41 -5e-11 \
    105.410001 0 105.45 0 105.450001 -5e-11 105.46 -5e-11 \
    105.460001 0 105.5 0 105.500001 -5e-11 105.51 -5e-11 \
    105.510001 0 105.55 0 105.550001 -5e-11 105.56 -5e-11 \
    105.560001 0 105.6 0 105.600001 -5e-11 105.61 -5e-11 \
    105.610001 0 105.65 0 105.650001 -5e-11 105.66 -5e-11 \
    105.660001 0 105.7 0 105.700001 -5e-11 105.71 -5e-11 \
    105.710001 0 105.75 0 105.750001 -5e-11 105.76 -5e-11 \
    105.760001 0 105.8 0 105.800001 -5e-11 105.81 -5e-11 \
    105.810001 0 105.85 0 105.850001 -5e-11 105.86 -5e-11 \
    105.860001 0 105.9 0 105.900001 -5e-11 105.91 -5e-11 \
    105.910001 0 105.95 0 105.950001 -5e-11 105.96 -5e-11 \
    105.960001 0 106 0 106.000001 -5e-11 106.01 -5e-11 \
    106.010001 0 106.05 0 106.050001 -5e-11 106.06 -5e-11 \
    106.060001 0 106.1 0 106.100001 -5e-11 106.11 -5e-11 \
    106.110001 0 106.15 0 106.150001 -5e-11 106.16 -5e-11 \
    106.160001 0 106.2 0 106.200001 -5e-11 106.21 -5e-11 \
    106.210001 0 106.25 0 106.250001 -5e-11 106.26 -5e-11 \
    106.260001 0 106.3 0 106.300001 -5e-11 106.31 -5e-11 \
    106.310001 0 106.35 0 106.350001 -5e-11 106.36 -5e-11 \
    106.360001 0 106.4 0 106.400001 -5e-11 106.41 -5e-11 \
    106.410001 0 106.45 0 106.450001 -5e-11 106.46 -5e-11 \
    106.460001 0 106.5 0 106.500001 -5e-11 106.51 -5e-11 \
    106.510001 0 106.55 0 106.550001 -5e-11 106.56 -5e-11 \
    106.560001 0 106.6 0 106.600001 -5e-11 106.61 -5e-11 \
    106.610001 0 106.65 0 106.650001 -5e-11 106.66 -5e-11 \
    106.660001 0 106.7 0 106.700001 -5e-11 106.71 -5e-11 \
    106.710001 0 106.75 0 106.750001 -5e-11 106.76 -5e-11 \
    106.760001 0 106.8 0 106.800001 -5e-11 106.81 -5e-11 \
    106.810001 0 106.85 0 106.850001 -5e-11 106.86 -5e-11 \
    106.860001 0 106.9 0 106.900001 -5e-11 106.91 -5e-11 \
    106.910001 0 106.95 0 106.950001 -5e-11 106.96 -5e-11 \
    106.960001 0 107 0 107.000001 -5e-11 107.01 -5e-11 \
    107.010001 0 107.05 0 107.050001 -5e-11 107.06 -5e-11 \
    107.060001 0 107.1 0 107.100001 -5e-11 107.11 -5e-11 \
    107.110001 0 107.15 0 107.150001 -5e-11 107.16 -5e-11 \
    107.160001 0 107.2 0 107.200001 -5e-11 107.21 -5e-11 \
    107.210001 0 107.25 0 107.250001 -5e-11 107.26 -5e-11 \
    107.260001 0 107.3 0 107.300001 -5e-11 107.31 -5e-11 \
    107.310001 0 107.35 0 107.350001 -5e-11 107.36 -5e-11 \
    107.360001 0 107.4 0 107.400001 -5e-11 107.41 -5e-11 \
    107.410001 0 107.45 0 107.450001 -5e-11 107.46 -5e-11 \
    107.460001 0 107.5 0 107.500001 -5e-11 107.51 -5e-11 \
    107.510001 0 107.55 0 107.550001 -5e-11 107.56 -5e-11 \
    107.560001 0 107.6 0 107.600001 -5e-11 107.61 -5e-11 \
    107.610001 0 107.65 0 107.650001 -5e-11 107.66 -5e-11 \
    107.660001 0 107.7 0 107.700001 -5e-11 107.71 -5e-11 \
    107.710001 0 107.75 0 107.750001 -5e-11 107.76 -5e-11 \
    107.760001 0 107.8 0 107.800001 -5e-11 107.81 -5e-11 \
    107.810001 0 107.85 0 107.850001 -5e-11 107.86 -5e-11 \
    107.860001 0 107.9 0 107.900001 -5e-11 107.91 -5e-11 \
    107.910001 0 107.95 0 107.950001 -5e-11 107.96 -5e-11 \
    107.960001 0 108 0 108.000001 -5e-11 108.01 -5e-11 \
    108.010001 0 108.05 0 108.050001 -5e-11 108.06 -5e-11 \
    108.060001 0 108.1 0 108.100001 -5e-11 108.11 -5e-11 \
    108.110001 0 108.15 0 108.150001 -5e-11 108.16 -5e-11 \
    108.160001 0 108.2 0 108.200001 -5e-11 108.21 -5e-11 \
    108.210001 0 108.25 0 108.250001 -5e-11 108.26 -5e-11 \
    108.260001 0 108.3 0 108.300001 -5e-11 108.31 -5e-11 \
    108.310001 0 108.35 0 108.350001 -5e-11 108.36 -5e-11 \
    108.360001 0 108.4 0 108.400001 -5e-11 108.41 -5e-11 \
    108.410001 0 108.45 0 108.450001 -5e-11 108.46 -5e-11 \
    108.460001 0 108.5 0 108.500001 -5e-11 108.51 -5e-11 \
    108.510001 0 108.55 0 108.550001 -5e-11 108.56 -5e-11 \
    108.560001 0 108.6 0 108.600001 -5e-11 108.61 -5e-11 \
    108.610001 0 108.65 0 108.650001 -5e-11 108.66 -5e-11 \
    108.660001 0 108.7 0 108.700001 -5e-11 108.71 -5e-11 \
    108.710001 0 108.75 0 108.750001 -5e-11 108.76 -5e-11 \
    108.760001 0 108.8 0 108.800001 -5e-11 108.81 -5e-11 \
    108.810001 0 108.85 0 108.850001 -5e-11 108.86 -5e-11 \
    108.860001 0 108.9 0 108.900001 -5e-11 108.91 -5e-11 \
    108.910001 0 108.95 0 108.950001 -5e-11 108.96 -5e-11 \
    108.960001 0 109 0 109.000001 -5e-11 109.01 -5e-11 \
    109.010001 0 109.05 0 109.050001 -5e-11 109.06 -5e-11 \
    109.060001 0 109.1 0 109.100001 -5e-11 109.11 -5e-11 \
    109.110001 0 109.15 0 109.150001 -5e-11 109.16 -5e-11 \
    109.160001 0 109.2 0 109.200001 -5e-11 109.21 -5e-11 \
    109.210001 0 109.25 0 109.250001 -5e-11 109.26 -5e-11 \
    109.260001 0 109.3 0 109.300001 -5e-11 109.31 -5e-11 \
    109.310001 0 109.35 0 109.350001 -5e-11 109.36 -5e-11 \
    109.360001 0 109.4 0 109.400001 -5e-11 109.41 -5e-11 \
    109.410001 0 109.45 0 109.450001 -5e-11 109.46 -5e-11 \
    109.460001 0 109.5 0 109.500001 -5e-11 109.51 -5e-11 \
    109.510001 0 109.55 0 109.550001 -5e-11 109.56 -5e-11 \
    109.560001 0 109.6 0 109.600001 -5e-11 109.61 -5e-11 \
    109.610001 0 109.65 0 109.650001 -5e-11 109.66 -5e-11 \
    109.660001 0 109.7 0 109.700001 -5e-11 109.71 -5e-11 \
    109.710001 0 109.75 0 109.750001 -5e-11 109.76 -5e-11 \
    109.760001 0 109.8 0 109.800001 -5e-11 109.81 -5e-11 \
    109.810001 0 109.85 0 109.850001 -5e-11 109.86 -5e-11 \
    109.860001 0 109.9 0 109.900001 -5e-11 109.91 -5e-11 \
    109.910001 0 109.95 0 109.950001 -5e-11 109.96 -5e-11 \
    109.960001 0 110 0 110.000001 -5e-11 110.01 -5e-11 \
    110.010001 0 110.05 0 110.050001 -5e-11 110.06 -5e-11 \
    110.060001 0 110.1 0 110.100001 -5e-11 110.11 -5e-11 \
    110.110001 0 110.15 0 110.150001 -5e-11 110.16 -5e-11 \
    110.160001 0 110.2 0 110.200001 -5e-11 110.21 -5e-11 \
    110.210001 0 110.25 0 110.250001 -5e-11 110.26 -5e-11 \
    110.260001 0 110.3 0 110.300001 -5e-11 110.31 -5e-11 \
    110.310001 0 110.35 0 110.350001 -5e-11 110.36 -5e-11 \
    110.360001 0 110.4 0 110.400001 -5e-11 110.41 -5e-11 \
    110.410001 0 110.45 0 110.450001 -5e-11 110.46 -5e-11 \
    110.460001 0 110.5 0 110.500001 -5e-11 110.51 -5e-11 \
    110.510001 0 110.55 0 110.550001 -5e-11 110.56 -5e-11 \
    110.560001 0 110.6 0 110.600001 -5e-11 110.61 -5e-11 \
    110.610001 0 110.65 0 110.650001 -5e-11 110.66 -5e-11 \
    110.660001 0 110.7 0 110.700001 -5e-11 110.71 -5e-11 \
    110.710001 0 110.75 0 110.750001 -5e-11 110.76 -5e-11 \
    110.760001 0 110.8 0 110.800001 -5e-11 110.81 -5e-11 \
    110.810001 0 110.85 0 110.850001 -5e-11 110.86 -5e-11 \
    110.860001 0 110.9 0 110.900001 -5e-11 110.91 -5e-11 \
    110.910001 0 110.95 0 110.950001 -5e-11 110.96 -5e-11 \
    110.960001 0 111 0 111.000001 -5e-11 111.01 -5e-11 \
    111.010001 0 111.05 0 111.050001 -5e-11 111.06 -5e-11 \
    111.060001 0 111.1 0 111.100001 -5e-11 111.11 -5e-11 \
    111.110001 0 111.15 0 111.150001 -5e-11 111.16 -5e-11 \
    111.160001 0 111.2 0 111.200001 -5e-11 111.21 -5e-11 \
    111.210001 0 111.25 0 111.250001 -5e-11 111.26 -5e-11 \
    111.260001 0 111.3 0 111.300001 -5e-11 111.31 -5e-11 \
    111.310001 0 111.35 0 111.350001 -5e-11 111.36 -5e-11 \
    111.360001 0 111.4 0 111.400001 -5e-11 111.41 -5e-11 \
    111.410001 0 111.45 0 111.450001 -5e-11 111.46 -5e-11 \
    111.460001 0 111.5 0 111.500001 -5e-11 111.51 -5e-11 \
    111.510001 0 111.55 0 111.550001 -5e-11 111.56 -5e-11 \
    111.560001 0 111.6 0 111.600001 -5e-11 111.61 -5e-11 \
    111.610001 0 111.65 0 111.650001 -5e-11 111.66 -5e-11 \
    111.660001 0 111.7 0 111.700001 -5e-11 111.71 -5e-11 \
    111.710001 0 111.75 0 111.750001 -5e-11 111.76 -5e-11 \
    111.760001 0 111.8 0 111.800001 -5e-11 111.81 -5e-11 \
    111.810001 0 111.85 0 111.850001 -5e-11 111.86 -5e-11 \
    111.860001 0 111.9 0 111.900001 -5e-11 111.91 -5e-11 \
    111.910001 0 111.95 0 111.950001 -5e-11 111.96 -5e-11 \
    111.960001 0 112 0 112.000001 -5e-11 112.01 -5e-11 \
    112.010001 0 112.05 0 112.050001 -5e-11 112.06 -5e-11 \
    112.060001 0 112.1 0 112.100001 -5e-11 112.11 -5e-11 \
    112.110001 0 112.15 0 112.150001 -5e-11 112.16 -5e-11 \
    112.160001 0 112.2 0 112.200001 -5e-11 112.21 -5e-11 \
    112.210001 0 112.25 0 112.250001 -5e-11 112.26 -5e-11 \
    112.260001 0 112.3 0 112.300001 -5e-11 112.31 -5e-11 \
    112.310001 0 112.35 0 112.350001 -5e-11 112.36 -5e-11 \
    112.360001 0 112.4 0 112.400001 -5e-11 112.41 -5e-11 \
    112.410001 0 112.45 0 112.450001 -5e-11 112.46 -5e-11 \
    112.460001 0 112.5 0 112.500001 -5e-11 112.51 -5e-11 \
    112.510001 0 112.55 0 112.550001 -5e-11 112.56 -5e-11 \
    112.560001 0 112.6 0 112.600001 -5e-11 112.61 -5e-11 \
    112.610001 0 112.65 0 112.650001 -5e-11 112.66 -5e-11 \
    112.660001 0 112.7 0 112.700001 -5e-11 112.71 -5e-11 \
    112.710001 0 112.75 0 112.750001 -5e-11 112.76 -5e-11 \
    112.760001 0 112.8 0 112.800001 -5e-11 112.81 -5e-11 \
    112.810001 0 112.85 0 112.850001 -5e-11 112.86 -5e-11 \
    112.860001 0 112.9 0 112.900001 -5e-11 112.91 -5e-11 \
    112.910001 0 112.95 0 112.950001 -5e-11 112.96 -5e-11 \
    112.960001 0 113 0 113.000001 -5e-11 113.01 -5e-11 \
    113.010001 0 113.05 0 113.050001 -5e-11 113.06 -5e-11 \
    113.060001 0 113.1 0 113.100001 -5e-11 113.11 -5e-11 \
    113.110001 0 113.15 0 113.150001 -5e-11 113.16 -5e-11 \
    113.160001 0 113.2 0 113.200001 -5e-11 113.21 -5e-11 \
    113.210001 0 113.25 0 113.250001 -5e-11 113.26 -5e-11 \
    113.260001 0 113.3 0 113.300001 -5e-11 113.31 -5e-11 \
    113.310001 0 113.35 0 113.350001 -5e-11 113.36 -5e-11 \
    113.360001 0 113.4 0 113.400001 -5e-11 113.41 -5e-11 \
    113.410001 0 113.45 0 113.450001 -5e-11 113.46 -5e-11 \
    113.460001 0 113.5 0 113.500001 -5e-11 113.51 -5e-11 \
    113.510001 0 113.55 0 113.550001 -5e-11 113.56 -5e-11 \
    113.560001 0 113.6 0 113.600001 -5e-11 113.61 -5e-11 \
    113.610001 0 113.65 0 113.650001 -5e-11 113.66 -5e-11 \
    113.660001 0 113.7 0 113.700001 -5e-11 113.71 -5e-11 \
    113.710001 0 113.75 0 113.750001 -5e-11 113.76 -5e-11 \
    113.760001 0 113.8 0 113.800001 -5e-11 113.81 -5e-11 \
    113.810001 0 113.85 0 113.850001 -5e-11 113.86 -5e-11 \
    113.860001 0 113.9 0 113.900001 -5e-11 113.91 -5e-11 \
    113.910001 0 113.95 0 113.950001 -5e-11 113.96 -5e-11 \
    113.960001 0 114 0 114.000001 -5e-11 114.01 -5e-11 \
    114.010001 0 114.05 0 114.050001 -5e-11 114.06 -5e-11 \
    114.060001 0 114.1 0 114.100001 -5e-11 114.11 -5e-11 \
    114.110001 0 114.15 0 114.150001 -5e-11 114.16 -5e-11 \
    114.160001 0 114.2 0 114.200001 -5e-11 114.21 -5e-11 \
    114.210001 0 114.25 0 114.250001 -5e-11 114.26 -5e-11 \
    114.260001 0 114.3 0 114.300001 -5e-11 114.31 -5e-11 \
    114.310001 0 114.35 0 114.350001 -5e-11 114.36 -5e-11 \
    114.360001 0 114.4 0 114.400001 -5e-11 114.41 -5e-11 \
    114.410001 0 114.45 0 114.450001 -5e-11 114.46 -5e-11 \
    114.460001 0 114.5 0 114.500001 -5e-11 114.51 -5e-11 \
    114.510001 0 114.55 0 114.550001 -5e-11 114.56 -5e-11 \
    114.560001 0 114.6 0 114.600001 -5e-11 114.61 -5e-11 \
    114.610001 0 114.65 0 114.650001 -5e-11 114.66 -5e-11 \
    114.660001 0 114.7 0 114.700001 -5e-11 114.71 -5e-11 \
    114.710001 0 114.75 0 114.750001 -5e-11 114.76 -5e-11 \
    114.760001 0 114.8 0 114.800001 -5e-11 114.81 -5e-11 \
    114.810001 0 114.85 0 114.850001 -5e-11 114.86 -5e-11 \
    114.860001 0 114.9 0 114.900001 -5e-11 114.91 -5e-11 \
    114.910001 0 114.95 0 114.950001 -5e-11 114.96 -5e-11 \
    114.960001 0 115 0 115.000001 -5e-11 115.01 -5e-11 \
    115.010001 0 115.05 0 115.050001 -5e-11 115.06 -5e-11 \
    115.060001 0 115.1 0 115.100001 -5e-11 115.11 -5e-11 \
    115.110001 0 115.15 0 115.150001 -5e-11 115.16 -5e-11 \
    115.160001 0 115.2 0 115.200001 -5e-11 115.21 -5e-11 \
    115.210001 0 115.25 0 115.250001 -5e-11 115.26 -5e-11 \
    115.260001 0 115.3 0 115.300001 -5e-11 115.31 -5e-11 \
    115.310001 0 115.35 0 115.350001 -5e-11 115.36 -5e-11 \
    115.360001 0 115.4 0 115.400001 -5e-11 115.41 -5e-11 \
    115.410001 0 115.45 0 115.450001 -5e-11 115.46 -5e-11 \
    115.460001 0 115.5 0 115.500001 -5e-11 115.51 -5e-11 \
    115.510001 0 115.55 0 115.550001 -5e-11 115.56 -5e-11 \
    115.560001 0 115.6 0 115.600001 -5e-11 115.61 -5e-11 \
    115.610001 0 115.65 0 115.650001 -5e-11 115.66 -5e-11 \
    115.660001 0 115.7 0 115.700001 -5e-11 115.71 -5e-11 \
    115.710001 0 115.75 0 115.750001 -5e-11 115.76 -5e-11 \
    115.760001 0 115.8 0 115.800001 -5e-11 115.81 -5e-11 \
    115.810001 0 115.85 0 115.850001 -5e-11 115.86 -5e-11 \
    115.860001 0 115.9 0 115.900001 -5e-11 115.91 -5e-11 \
    115.910001 0 115.95 0 115.950001 -5e-11 115.96 -5e-11 \
    115.960001 0 116 0 116.000001 -5e-11 116.01 -5e-11 \
    116.010001 0 116.05 0 116.050001 -5e-11 116.06 -5e-11 \
    116.060001 0 116.1 0 116.100001 -5e-11 116.11 -5e-11 \
    116.110001 0 116.15 0 116.150001 -5e-11 116.16 -5e-11 \
    116.160001 0 116.2 0 116.200001 -5e-11 116.21 -5e-11 \
    116.210001 0 116.25 0 116.250001 -5e-11 116.26 -5e-11 \
    116.260001 0 116.3 0 116.300001 -5e-11 116.31 -5e-11 \
    116.310001 0 116.35 0 116.350001 -5e-11 116.36 -5e-11 \
    116.360001 0 116.4 0 116.400001 -5e-11 116.41 -5e-11 \
    116.410001 0 116.45 0 116.450001 -5e-11 116.46 -5e-11 \
    116.460001 0 116.5 0 116.500001 -5e-11 116.51 -5e-11 \
    116.510001 0 116.55 0 116.550001 -5e-11 116.56 -5e-11 \
    116.560001 0 116.6 0 116.600001 -5e-11 116.61 -5e-11 \
    116.610001 0 116.65 0 116.650001 -5e-11 116.66 -5e-11 \
    116.660001 0 116.7 0 116.700001 -5e-11 116.71 -5e-11 \
    116.710001 0 116.75 0 116.750001 -5e-11 116.76 -5e-11 \
    116.760001 0 116.8 0 116.800001 -5e-11 116.81 -5e-11 \
    116.810001 0 116.85 0 116.850001 -5e-11 116.86 -5e-11 \
    116.860001 0 116.9 0 116.900001 -5e-11 116.91 -5e-11 \
    116.910001 0 116.95 0 116.950001 -5e-11 116.96 -5e-11 \
    116.960001 0 117 0 117.000001 -5e-11 117.01 -5e-11 \
    117.010001 0 117.05 0 117.050001 -5e-11 117.06 -5e-11 \
    117.060001 0 117.1 0 117.100001 -5e-11 117.11 -5e-11 \
    117.110001 0 117.15 0 117.150001 -5e-11 117.16 -5e-11 \
    117.160001 0 117.2 0 117.200001 -5e-11 117.21 -5e-11 \
    117.210001 0 117.25 0 117.250001 -5e-11 117.26 -5e-11 \
    117.260001 0 117.3 0 117.300001 -5e-11 117.31 -5e-11 \
    117.310001 0 117.35 0 117.350001 -5e-11 117.36 -5e-11 \
    117.360001 0 117.4 0 117.400001 -5e-11 117.41 -5e-11 \
    117.410001 0 117.45 0 117.450001 -5e-11 117.46 -5e-11 \
    117.460001 0 117.5 0 117.500001 -5e-11 117.51 -5e-11 \
    117.510001 0 117.55 0 117.550001 -5e-11 117.56 -5e-11 \
    117.560001 0 117.6 0 117.600001 -5e-11 117.61 -5e-11 \
    117.610001 0 117.65 0 117.650001 -5e-11 117.66 -5e-11 \
    117.660001 0 117.7 0 117.700001 -5e-11 117.71 -5e-11 \
    117.710001 0 117.75 0 117.750001 -5e-11 117.76 -5e-11 \
    117.760001 0 117.8 0 117.800001 -5e-11 117.81 -5e-11 \
    117.810001 0 117.85 0 117.850001 -5e-11 117.86 -5e-11 \
    117.860001 0 117.9 0 117.900001 -5e-11 117.91 -5e-11 \
    117.910001 0 117.95 0 117.950001 -5e-11 117.96 -5e-11 \
    117.960001 0 118 0 118.000001 -5e-11 118.01 -5e-11 \
    118.010001 0 118.05 0 118.050001 -5e-11 118.06 -5e-11 \
    118.060001 0 118.1 0 118.100001 -5e-11 118.11 -5e-11 \
    118.110001 0 118.15 0 118.150001 -5e-11 118.16 -5e-11 \
    118.160001 0 118.2 0 118.200001 -5e-11 118.21 -5e-11 \
    118.210001 0 118.25 0 118.250001 -5e-11 118.26 -5e-11 \
    118.260001 0 118.3 0 118.300001 -5e-11 118.31 -5e-11 \
    118.310001 0 118.35 0 118.350001 -5e-11 118.36 -5e-11 \
    118.360001 0 118.4 0 118.400001 -5e-11 118.41 -5e-11 \
    118.410001 0 118.45 0 118.450001 -5e-11 118.46 -5e-11 \
    118.460001 0 118.5 0 118.500001 -5e-11 118.51 -5e-11 \
    118.510001 0 118.55 0 118.550001 -5e-11 118.56 -5e-11 \
    118.560001 0 118.6 0 118.600001 -5e-11 118.61 -5e-11 \
    118.610001 0 118.65 0 118.650001 -5e-11 118.66 -5e-11 \
    118.660001 0 118.7 0 118.700001 -5e-11 118.71 -5e-11 \
    118.710001 0 118.75 0 118.750001 -5e-11 118.76 -5e-11 \
    118.760001 0 118.8 0 118.800001 -5e-11 118.81 -5e-11 \
    118.810001 0 118.85 0 118.850001 -5e-11 118.86 -5e-11 \
    118.860001 0 118.9 0 118.900001 -5e-11 118.91 -5e-11 \
    118.910001 0 118.95 0 118.950001 -5e-11 118.96 -5e-11 \
    118.960001 0 119 0 119.000001 -5e-11 119.01 -5e-11 \
    119.010001 0 119.05 0 119.050001 -5e-11 119.06 -5e-11 \
    119.060001 0 119.1 0 119.100001 -5e-11 119.11 -5e-11 \
    119.110001 0 119.15 0 119.150001 -5e-11 119.16 -5e-11 \
    119.160001 0 119.2 0 119.200001 -5e-11 119.21 -5e-11 \
    119.210001 0 119.25 0 119.250001 -5e-11 119.26 -5e-11 \
    119.260001 0 119.3 0 119.300001 -5e-11 119.31 -5e-11 \
    119.310001 0 119.35 0 119.350001 -5e-11 119.36 -5e-11 \
    119.360001 0 119.4 0 119.400001 -5e-11 119.41 -5e-11 \
    119.410001 0 119.45 0 119.450001 -5e-11 119.46 -5e-11 \
    119.460001 0 119.5 0 119.500001 -5e-11 119.51 -5e-11 \
    119.510001 0 119.55 0 119.550001 -5e-11 119.56 -5e-11 \
    119.560001 0 119.6 0 119.600001 -5e-11 119.61 -5e-11 \
    119.610001 0 119.65 0 119.650001 -5e-11 119.66 -5e-11 \
    119.660001 0 119.7 0 119.700001 -5e-11 119.71 -5e-11 \
    119.710001 0 119.75 0 119.750001 -5e-11 119.76 -5e-11 \
    119.760001 0 119.8 0 119.800001 -5e-11 119.81 -5e-11 \
    119.810001 0 119.85 0 119.850001 -5e-11 119.86 -5e-11 \
    119.860001 0 119.9 0 119.900001 -5e-11 119.91 -5e-11 \
    119.910001 0 119.95 0 119.950001 -5e-11 119.96 -5e-11 \
    119.960001 0 120 0 120.000001 -5e-11 120.01 -5e-11 \
    120.010001 0 120.05 0 120.050001 -5e-11 120.06 -5e-11 \
    120.060001 0 120.1 0 120.100001 -5e-11 120.11 -5e-11 \
    120.110001 0 120.15 0 120.150001 -5e-11 120.16 -5e-11 \
    120.160001 0 120.2 0 120.200001 -5e-11 120.21 -5e-11 \
    120.210001 0 120.25 0 120.250001 -5e-11 120.26 -5e-11 \
    120.260001 0 120.3 0 120.300001 -5e-11 120.31 -5e-11 \
    120.310001 0 120.35 0 120.350001 -5e-11 120.36 -5e-11 \
    120.360001 0 120.4 0 120.400001 -5e-11 120.41 -5e-11 \
    120.410001 0 120.45 0 120.450001 -5e-11 120.46 -5e-11 \
    120.460001 0 120.5 0 120.500001 -5e-11 120.51 -5e-11 \
    120.510001 0 120.55 0 120.550001 -5e-11 120.56 -5e-11 \
    120.560001 0 120.6 0 120.600001 -5e-11 120.61 -5e-11 \
    120.610001 0 120.65 0 120.650001 -5e-11 120.66 -5e-11 \
    120.660001 0 120.7 0 120.700001 -5e-11 120.71 -5e-11 \
    120.710001 0 120.75 0 120.750001 -5e-11 120.76 -5e-11 \
    120.760001 0 120.8 0 120.800001 -5e-11 120.81 -5e-11 \
    120.810001 0 120.85 0 120.850001 -5e-11 120.86 -5e-11 \
    120.860001 0 120.9 0 120.900001 -5e-11 120.91 -5e-11 \
    120.910001 0 120.95 0 120.950001 -5e-11 120.96 -5e-11 \
    120.960001 0 121 0 121.000001 -5e-11 121.01 -5e-11 \
    121.010001 0 121.05 0 121.050001 -5e-11 121.06 -5e-11 \
    121.060001 0 121.1 0 121.100001 -5e-11 121.11 -5e-11 \
    121.110001 0 121.15 0 121.150001 -5e-11 121.16 -5e-11 \
    121.160001 0 121.2 0 121.200001 -5e-11 121.21 -5e-11 \
    121.210001 0 121.25 0 121.250001 -5e-11 121.26 -5e-11 \
    121.260001 0 121.3 0 121.300001 -5e-11 121.31 -5e-11 \
    121.310001 0 121.35 0 121.350001 -5e-11 121.36 -5e-11 \
    121.360001 0 121.4 0 121.400001 -5e-11 121.41 -5e-11 \
    121.410001 0 121.45 0 121.450001 -5e-11 121.46 -5e-11 \
    121.460001 0 121.5 0 121.500001 -5e-11 121.51 -5e-11 \
    121.510001 0 121.55 0 121.550001 -5e-11 121.56 -5e-11 \
    121.560001 0 121.6 0 121.600001 -5e-11 121.61 -5e-11 \
    121.610001 0 121.65 0 121.650001 -5e-11 121.66 -5e-11 \
    121.660001 0 121.7 0 121.700001 -5e-11 121.71 -5e-11 \
    121.710001 0 121.75 0 121.750001 -5e-11 121.76 -5e-11 \
    121.760001 0 121.8 0 121.800001 -5e-11 121.81 -5e-11 \
    121.810001 0 121.85 0 121.850001 -5e-11 121.86 -5e-11 \
    121.860001 0 121.9 0 121.900001 -5e-11 121.91 -5e-11 \
    121.910001 0 121.95 0 121.950001 -5e-11 121.96 -5e-11 \
    121.960001 0 122 0 122.000001 -5e-11 122.01 -5e-11 \
    122.010001 0 122.05 0 122.050001 -5e-11 122.06 -5e-11 \
    122.060001 0 122.1 0 122.100001 -5e-11 122.11 -5e-11 \
    122.110001 0 122.15 0 122.150001 -5e-11 122.16 -5e-11 \
    122.160001 0 122.2 0 122.200001 -5e-11 122.21 -5e-11 \
    122.210001 0 122.25 0 122.250001 -5e-11 122.26 -5e-11 \
    122.260001 0 122.3 0 122.300001 -5e-11 122.31 -5e-11 \
    122.310001 0 122.35 0 122.350001 -5e-11 122.36 -5e-11 \
    122.360001 0 122.4 0 122.400001 -5e-11 122.41 -5e-11 \
    122.410001 0 122.45 0 122.450001 -5e-11 122.46 -5e-11 \
    122.460001 0 122.5 0 122.500001 -5e-11 122.51 -5e-11 \
    122.510001 0 122.55 0 122.550001 -5e-11 122.56 -5e-11 \
    122.560001 0 122.6 0 122.600001 -5e-11 122.61 -5e-11 \
    122.610001 0 122.65 0 122.650001 -5e-11 122.66 -5e-11 \
    122.660001 0 122.7 0 122.700001 -5e-11 122.71 -5e-11 \
    122.710001 0 122.75 0 122.750001 -5e-11 122.76 -5e-11 \
    122.760001 0 122.8 0 122.800001 -5e-11 122.81 -5e-11 \
    122.810001 0 122.85 0 122.850001 -5e-11 122.86 -5e-11 \
    122.860001 0 122.9 0 122.900001 -5e-11 122.91 -5e-11 \
    122.910001 0 122.95 0 122.950001 -5e-11 122.96 -5e-11 \
    122.960001 0 123 0 123.000001 -5e-11 123.01 -5e-11 \
    123.010001 0 123.05 0 123.050001 -5e-11 123.06 -5e-11 \
    123.060001 0 123.1 0 123.100001 -5e-11 123.11 -5e-11 \
    123.110001 0 123.15 0 123.150001 -5e-11 123.16 -5e-11 \
    123.160001 0 123.2 0 123.200001 -5e-11 123.21 -5e-11 \
    123.210001 0 123.25 0 123.250001 -5e-11 123.26 -5e-11 \
    123.260001 0 123.3 0 123.300001 -5e-11 123.31 -5e-11 \
    123.310001 0 123.35 0 123.350001 -5e-11 123.36 -5e-11 \
    123.360001 0 123.4 0 123.400001 -5e-11 123.41 -5e-11 \
    123.410001 0 123.45 0 123.450001 -5e-11 123.46 -5e-11 \
    123.460001 0 123.5 0 123.500001 -5e-11 123.51 -5e-11 \
    123.510001 0 123.55 0 123.550001 -5e-11 123.56 -5e-11 \
    123.560001 0 123.6 0 123.600001 -5e-11 123.61 -5e-11 \
    123.610001 0 123.65 0 123.650001 -5e-11 123.66 -5e-11 \
    123.660001 0 123.7 0 123.700001 -5e-11 123.71 -5e-11 \
    123.710001 0 123.75 0 123.750001 -5e-11 123.76 -5e-11 \
    123.760001 0 123.8 0 123.800001 -5e-11 123.81 -5e-11 \
    123.810001 0 123.85 0 123.850001 -5e-11 123.86 -5e-11 \
    123.860001 0 123.9 0 123.900001 -5e-11 123.91 -5e-11 \
    123.910001 0 123.95 0 123.950001 -5e-11 123.96 -5e-11 \
    123.960001 0 124 0 124.000001 -5e-11 124.01 -5e-11 \
    124.010001 0 124.05 0 124.050001 -5e-11 124.06 -5e-11 \
    124.060001 0 124.1 0 124.100001 -5e-11 124.11 -5e-11 \
    124.110001 0 124.15 0 124.150001 -5e-11 124.16 -5e-11 \
    124.160001 0 124.2 0 124.200001 -5e-11 124.21 -5e-11 \
    124.210001 0 124.25 0 124.250001 -5e-11 124.26 -5e-11 \
    124.260001 0 124.3 0 124.300001 -5e-11 124.31 -5e-11 \
    124.310001 0 124.35 0 124.350001 -5e-11 124.36 -5e-11 \
    124.360001 0 124.4 0 124.400001 -5e-11 124.41 -5e-11 \
    124.410001 0 124.45 0 124.450001 -5e-11 124.46 -5e-11 \
    124.460001 0 124.5 0 124.500001 -5e-11 124.51 -5e-11 \
    124.510001 0 124.55 0 124.550001 -5e-11 124.56 -5e-11 \
    124.560001 0 124.6 0 124.600001 -5e-11 124.61 -5e-11 \
    124.610001 0 124.65 0 124.650001 -5e-11 124.66 -5e-11 \
    124.660001 0 124.7 0 124.700001 -5e-11 124.71 -5e-11 \
    124.710001 0 124.75 0 124.750001 -5e-11 124.76 -5e-11 \
    124.760001 0 124.8 0 124.800001 -5e-11 124.81 -5e-11 \
    124.810001 0 124.85 0 124.850001 -5e-11 124.86 -5e-11 \
    124.860001 0 124.9 0 124.900001 -5e-11 124.91 -5e-11 \
    124.910001 0 124.95 0 124.950001 -5e-11 124.96 -5e-11 \
    124.960001 0 125 0 125.000001 -5e-11 125.01 -5e-11 \
    125.010001 0 125.05 0 125.050001 -5e-11 125.06 -5e-11 \
    125.060001 0 125.1 0 125.100001 -5e-11 125.11 -5e-11 \
    125.110001 0 125.15 0 125.150001 -5e-11 125.16 -5e-11 \
    125.160001 0 125.2 0 125.200001 -5e-11 125.21 -5e-11 \
    125.210001 0 125.25 0 125.250001 -5e-11 125.26 -5e-11 \
    125.260001 0 125.3 0 125.300001 -5e-11 125.31 -5e-11 \
    125.310001 0 125.35 0 125.350001 -5e-11 125.36 -5e-11 \
    125.360001 0 125.4 0 125.400001 -5e-11 125.41 -5e-11 \
    125.410001 0 125.45 0 125.450001 -5e-11 125.46 -5e-11 \
    125.460001 0 125.5 0 125.500001 -5e-11 125.51 -5e-11 \
    125.510001 0 125.55 0 125.550001 -5e-11 125.56 -5e-11 \
    125.560001 0 125.6 0 125.600001 -5e-11 125.61 -5e-11 \
    125.610001 0 125.65 0 125.650001 -5e-11 125.66 -5e-11 \
    125.660001 0 125.7 0 125.700001 -5e-11 125.71 -5e-11 \
    125.710001 0 125.75 0 125.750001 -5e-11 125.76 -5e-11 \
    125.760001 0 125.8 0 125.800001 -5e-11 125.81 -5e-11 \
    125.810001 0 125.85 0 125.850001 -5e-11 125.86 -5e-11 \
    125.860001 0 125.9 0 125.900001 -5e-11 125.91 -5e-11 \
    125.910001 0 125.95 0 125.950001 -5e-11 125.96 -5e-11 \
    125.960001 0 126 0 126.000001 -5e-11 126.01 -5e-11 \
    126.010001 0 126.05 0 126.050001 -5e-11 126.06 -5e-11 \
    126.060001 0 126.1 0 126.100001 -5e-11 126.11 -5e-11 \
    126.110001 0 126.15 0 126.150001 -5e-11 126.16 -5e-11 \
    126.160001 0 126.2 0 126.200001 -5e-11 126.21 -5e-11 \
    126.210001 0 126.25 0 126.250001 -5e-11 126.26 -5e-11 \
    126.260001 0 126.3 0 126.300001 -5e-11 126.31 -5e-11 \
    126.310001 0 126.35 0 126.350001 -5e-11 126.36 -5e-11 \
    126.360001 0 126.4 0 126.400001 -5e-11 126.41 -5e-11 \
    126.410001 0 126.45 0 126.450001 -5e-11 126.46 -5e-11 \
    126.460001 0 126.5 0 126.500001 -5e-11 126.51 -5e-11 \
    126.510001 0 126.55 0 126.550001 -5e-11 126.56 -5e-11 \
    126.560001 0 126.6 0 126.600001 -5e-11 126.61 -5e-11 \
    126.610001 0 126.65 0 126.650001 -5e-11 126.66 -5e-11 \
    126.660001 0 126.7 0 126.700001 -5e-11 126.71 -5e-11 \
    126.710001 0 126.75 0 126.750001 -5e-11 126.76 -5e-11 \
    126.760001 0 126.8 0 126.800001 -5e-11 126.81 -5e-11 \
    126.810001 0 126.85 0 126.850001 -5e-11 126.86 -5e-11 \
    126.860001 0 126.9 0 126.900001 -5e-11 126.91 -5e-11 \
    126.910001 0 126.95 0 126.950001 -5e-11 126.96 -5e-11 \
    126.960001 0 127 0 127.000001 -5e-11 127.01 -5e-11 \
    127.010001 0 127.05 0 127.050001 -5e-11 127.06 -5e-11 \
    127.060001 0 127.1 0 127.100001 -5e-11 127.11 -5e-11 \
    127.110001 0 127.15 0 127.150001 -5e-11 127.16 -5e-11 \
    127.160001 0 127.2 0 127.200001 -5e-11 127.21 -5e-11 \
    127.210001 0 127.25 0 127.250001 -5e-11 127.26 -5e-11 \
    127.260001 0 127.3 0 127.300001 -5e-11 127.31 -5e-11 \
    127.310001 0 127.35 0 127.350001 -5e-11 127.36 -5e-11 \
    127.360001 0 127.4 0 127.400001 -5e-11 127.41 -5e-11 \
    127.410001 0 127.45 0 127.450001 -5e-11 127.46 -5e-11 \
    127.460001 0 127.5 0 127.500001 -5e-11 127.51 -5e-11 \
    127.510001 0 127.55 0 127.550001 -5e-11 127.56 -5e-11 \
    127.560001 0 127.6 0 127.600001 -5e-11 127.61 -5e-11 \
    127.610001 0 127.65 0 127.650001 -5e-11 127.66 -5e-11 \
    127.660001 0 127.7 0 127.700001 -5e-11 127.71 -5e-11 \
    127.710001 0 127.75 0 127.750001 -5e-11 127.76 -5e-11 \
    127.760001 0 127.8 0 127.800001 -5e-11 127.81 -5e-11 \
    127.810001 0 127.85 0 127.850001 -5e-11 127.86 -5e-11 \
    127.860001 0 127.9 0 127.900001 -5e-11 127.91 -5e-11 \
    127.910001 0 127.95 0 127.950001 -5e-11 127.96 -5e-11 \
    127.960001 0 128 0 128.000001 -5e-11 128.01 -5e-11 \
    128.010001 0 128.05 0 128.050001 -5e-11 128.06 -5e-11 \
    128.060001 0 128.1 0 128.100001 -5e-11 128.11 -5e-11 \
    128.110001 0 128.15 0 128.150001 -5e-11 128.16 -5e-11 \
    128.160001 0 128.2 0 128.200001 -5e-11 128.21 -5e-11 \
    128.210001 0 128.25 0 128.250001 -5e-11 128.26 -5e-11 \
    128.260001 0 128.3 0 128.300001 -5e-11 128.31 -5e-11 \
    128.310001 0 128.35 0 128.350001 -5e-11 128.36 -5e-11 \
    128.360001 0 128.4 0 128.400001 -5e-11 128.41 -5e-11 \
    128.410001 0 128.45 0 128.450001 -5e-11 128.46 -5e-11 \
    128.460001 0 128.5 0 128.500001 -5e-11 128.51 -5e-11 \
    128.510001 0 128.55 0 128.550001 -5e-11 128.56 -5e-11 \
    128.560001 0 128.6 0 128.600001 -5e-11 128.61 -5e-11 \
    128.610001 0 128.65 0 128.650001 -5e-11 128.66 -5e-11 \
    128.660001 0 128.7 0 128.700001 -5e-11 128.71 -5e-11 \
    128.710001 0 128.75 0 128.750001 -5e-11 128.76 -5e-11 \
    128.760001 0 128.8 0 128.800001 -5e-11 128.81 -5e-11 \
    128.810001 0 128.85 0 128.850001 -5e-11 128.86 -5e-11 \
    128.860001 0 128.9 0 128.900001 -5e-11 128.91 -5e-11 \
    128.910001 0 128.95 0 128.950001 -5e-11 128.96 -5e-11 \
    128.960001 0 129 0 129.000001 -5e-11 129.01 -5e-11 \
    129.010001 0 129.05 0 129.050001 -5e-11 129.06 -5e-11 \
    129.060001 0 129.1 0 129.100001 -5e-11 129.11 -5e-11 \
    129.110001 0 129.15 0 129.150001 -5e-11 129.16 -5e-11 \
    129.160001 0 129.2 0 129.200001 -5e-11 129.21 -5e-11 \
    129.210001 0 129.25 0 129.250001 -5e-11 129.26 -5e-11 \
    129.260001 0 129.3 0 129.300001 -5e-11 129.31 -5e-11 \
    129.310001 0 129.35 0 129.350001 -5e-11 129.36 -5e-11 \
    129.360001 0 129.4 0 129.400001 -5e-11 129.41 -5e-11 \
    129.410001 0 129.45 0 129.450001 -5e-11 129.46 -5e-11 \
    129.460001 0 129.5 0 129.500001 -5e-11 129.51 -5e-11 \
    129.510001 0 129.55 0 129.550001 -5e-11 129.56 -5e-11 \
    129.560001 0 129.6 0 129.600001 -5e-11 129.61 -5e-11 \
    129.610001 0 129.65 0 129.650001 -5e-11 129.66 -5e-11 \
    129.660001 0 129.7 0 129.700001 -5e-11 129.71 -5e-11 \
    129.710001 0 129.75 0 129.750001 -5e-11 129.76 -5e-11 \
    129.760001 0 129.8 0 129.800001 -5e-11 129.81 -5e-11 \
    129.810001 0 129.85 0 129.850001 -5e-11 129.86 -5e-11 \
    129.860001 0 129.9 0 129.900001 -5e-11 129.91 -5e-11 \
    129.910001 0 129.95 0 129.950001 -5e-11 129.96 -5e-11 \
    129.960001 0 130 0 130.000001 -5e-11 130.01 -5e-11 \
    130.010001 0 130.05 0 130.050001 -5e-11 130.06 -5e-11 \
    130.060001 0 130.1 0 130.100001 -5e-11 130.11 -5e-11 \
    130.110001 0 130.15 0 130.150001 -5e-11 130.16 -5e-11 \
    130.160001 0 130.2 0 130.200001 -5e-11 130.21 -5e-11 \
    130.210001 0 130.25 0 130.250001 -5e-11 130.26 -5e-11 \
    130.260001 0 130.3 0 130.300001 -5e-11 130.31 -5e-11 \
    130.310001 0 130.35 0 130.350001 -5e-11 130.36 -5e-11 \
    130.360001 0 130.4 0 130.400001 -5e-11 130.41 -5e-11 \
    130.410001 0 130.45 0 130.450001 -5e-11 130.46 -5e-11 \
    130.460001 0 130.5 0 130.500001 -5e-11 130.51 -5e-11 \
    130.510001 0 130.55 0 130.550001 -5e-11 130.56 -5e-11 \
    130.560001 0 130.6 0 130.600001 -5e-11 130.61 -5e-11 \
    130.610001 0 130.65 0 130.650001 -5e-11 130.66 -5e-11 \
    130.660001 0 130.7 0 130.700001 -5e-11 130.71 -5e-11 \
    130.710001 0 130.75 0 130.750001 -5e-11 130.76 -5e-11 \
    130.760001 0 130.8 0 130.800001 -5e-11 130.81 -5e-11 \
    130.810001 0 130.85 0 130.850001 -5e-11 130.86 -5e-11 \
    130.860001 0 130.9 0 130.900001 -5e-11 130.91 -5e-11 \
    130.910001 0 130.95 0 130.950001 -5e-11 130.96 -5e-11 \
    130.960001 0 131 0 131.000001 -5e-11 131.01 -5e-11 \
    131.010001 0 131.05 0 131.050001 -5e-11 131.06 -5e-11 \
    131.060001 0 131.1 0 131.100001 -5e-11 131.11 -5e-11 \
    131.110001 0 131.15 0 131.150001 -5e-11 131.16 -5e-11 \
    131.160001 0 131.2 0 131.200001 -5e-11 131.21 -5e-11 \
    131.210001 0 131.25 0 131.250001 -5e-11 131.26 -5e-11 \
    131.260001 0 131.3 0 131.300001 -5e-11 131.31 -5e-11 \
    131.310001 0 131.35 0 131.350001 -5e-11 131.36 -5e-11 \
    131.360001 0 131.4 0 131.400001 -5e-11 131.41 -5e-11 \
    131.410001 0 131.45 0 131.450001 -5e-11 131.46 -5e-11 \
    131.460001 0 131.5 0 131.500001 -5e-11 131.51 -5e-11 \
    131.510001 0 131.55 0 131.550001 -5e-11 131.56 -5e-11 \
    131.560001 0 131.6 0 131.600001 -5e-11 131.61 -5e-11 \
    131.610001 0 131.65 0 131.650001 -5e-11 131.66 -5e-11 \
    131.660001 0 131.7 0 131.700001 -5e-11 131.71 -5e-11 \
    131.710001 0 131.75 0 131.750001 -5e-11 131.76 -5e-11 \
    131.760001 0 131.8 0 131.800001 -5e-11 131.81 -5e-11 \
    131.810001 0 131.85 0 131.850001 -5e-11 131.86 -5e-11 \
    131.860001 0 131.9 0 131.900001 -5e-11 131.91 -5e-11 \
    131.910001 0 131.95 0 131.950001 -5e-11 131.96 -5e-11 \
    131.960001 0 132 0 132.000001 -5e-11 132.01 -5e-11 \
    132.010001 0 132.05 0 132.050001 -5e-11 132.06 -5e-11 \
    132.060001 0 132.1 0 132.100001 -5e-11 132.11 -5e-11 \
    132.110001 0 132.15 0 132.150001 -5e-11 132.16 -5e-11 \
    132.160001 0 132.2 0 132.200001 -5e-11 132.21 -5e-11 \
    132.210001 0 132.25 0 132.250001 -5e-11 132.26 -5e-11 \
    132.260001 0 132.3 0 132.300001 -5e-11 132.31 -5e-11 \
    132.310001 0 132.35 0 132.350001 -5e-11 132.36 -5e-11 \
    132.360001 0 132.4 0 132.400001 -5e-11 132.41 -5e-11 \
    132.410001 0 132.45 0 132.450001 -5e-11 132.46 -5e-11 \
    132.460001 0 132.5 0 132.500001 -5e-11 132.51 -5e-11 \
    132.510001 0 132.55 0 132.550001 -5e-11 132.56 -5e-11 \
    132.560001 0 132.6 0 132.600001 -5e-11 132.61 -5e-11 \
    132.610001 0 132.65 0 132.650001 -5e-11 132.66 -5e-11 \
    132.660001 0 132.7 0 132.700001 -5e-11 132.71 -5e-11 \
    132.710001 0 132.75 0 132.750001 -5e-11 132.76 -5e-11 \
    132.760001 0 132.8 0 132.800001 -5e-11 132.81 -5e-11 \
    132.810001 0 132.85 0 132.850001 -5e-11 132.86 -5e-11 \
    132.860001 0 132.9 0 132.900001 -5e-11 132.91 -5e-11 \
    132.910001 0 132.95 0 132.950001 -5e-11 132.96 -5e-11 \
    132.960001 0 133 0 133.000001 -5e-11 133.01 -5e-11 \
    133.010001 0 133.05 0 133.050001 -5e-11 133.06 -5e-11 \
    133.060001 0 133.1 0 133.100001 -5e-11 133.11 -5e-11 \
    133.110001 0 133.15 0 133.150001 -5e-11 133.16 -5e-11 \
    133.160001 0 133.2 0 133.200001 -5e-11 133.21 -5e-11 \
    133.210001 0 133.25 0 133.250001 -5e-11 133.26 -5e-11 \
    133.260001 0 133.3 0 133.300001 -5e-11 133.31 -5e-11 \
    133.310001 0 133.35 0 133.350001 -5e-11 133.36 -5e-11 \
    133.360001 0 133.4 0 133.400001 -5e-11 133.41 -5e-11 \
    133.410001 0 133.45 0 133.450001 -5e-11 133.46 -5e-11 \
    133.460001 0 133.5 0 133.500001 -5e-11 133.51 -5e-11 \
    133.510001 0 133.55 0 133.550001 -5e-11 133.56 -5e-11 \
    133.560001 0 133.6 0 133.600001 -5e-11 133.61 -5e-11 \
    133.610001 0 133.65 0 133.650001 -5e-11 133.66 -5e-11 \
    133.660001 0 133.7 0 133.700001 -5e-11 133.71 -5e-11 \
    133.710001 0 133.75 0 133.750001 -5e-11 133.76 -5e-11 \
    133.760001 0 133.8 0 133.800001 -5e-11 133.81 -5e-11 \
    133.810001 0 133.85 0 133.850001 -5e-11 133.86 -5e-11 \
    133.860001 0 133.9 0 133.900001 -5e-11 133.91 -5e-11 \
    133.910001 0 133.95 0 133.950001 -5e-11 133.96 -5e-11 \
    133.960001 0 134 0 134.000001 -5e-11 134.01 -5e-11 \
    134.010001 0 134.05 0 134.050001 -5e-11 134.06 -5e-11 \
    134.060001 0 134.1 0 134.100001 -5e-11 134.11 -5e-11 \
    134.110001 0 134.15 0 134.150001 -5e-11 134.16 -5e-11 \
    134.160001 0 134.2 0 134.200001 -5e-11 134.21 -5e-11 \
    134.210001 0 134.25 0 134.250001 -5e-11 134.26 -5e-11 \
    134.260001 0 134.3 0 134.300001 -5e-11 134.31 -5e-11 \
    134.310001 0 134.35 0 134.350001 -5e-11 134.36 -5e-11 \
    134.360001 0 134.4 0 134.400001 -5e-11 134.41 -5e-11 \
    134.410001 0 134.45 0 134.450001 -5e-11 134.46 -5e-11 \
    134.460001 0 134.5 0 134.500001 -5e-11 134.51 -5e-11 \
    134.510001 0 134.55 0 134.550001 -5e-11 134.56 -5e-11 \
    134.560001 0 134.6 0 134.600001 -5e-11 134.61 -5e-11 \
    134.610001 0 134.65 0 134.650001 -5e-11 134.66 -5e-11 \
    134.660001 0 134.7 0 134.700001 -5e-11 134.71 -5e-11 \
    134.710001 0 134.75 0 134.750001 -5e-11 134.76 -5e-11 \
    134.760001 0 134.8 0 134.800001 -5e-11 134.81 -5e-11 \
    134.810001 0 134.85 0 134.850001 -5e-11 134.86 -5e-11 \
    134.860001 0 134.9 0 134.900001 -5e-11 134.91 -5e-11 \
    134.910001 0 134.95 0 134.950001 -5e-11 134.96 -5e-11 \
    134.960001 0 135 0 135.000001 -5e-11 135.01 -5e-11 \
    135.010001 0 135.05 0 135.050001 -5e-11 135.06 -5e-11 \
    135.060001 0 135.1 0 135.100001 -5e-11 135.11 -5e-11 \
    135.110001 0 135.15 0 135.150001 -5e-11 135.16 -5e-11 \
    135.160001 0 135.2 0 135.200001 -5e-11 135.21 -5e-11 \
    135.210001 0 135.25 0 135.250001 -5e-11 135.26 -5e-11 \
    135.260001 0 135.3 0 135.300001 -5e-11 135.31 -5e-11 \
    135.310001 0 135.35 0 135.350001 -5e-11 135.36 -5e-11 \
    135.360001 0 135.4 0 135.400001 -5e-11 135.41 -5e-11 \
    135.410001 0 135.45 0 135.450001 -5e-11 135.46 -5e-11 \
    135.460001 0 135.5 0 135.500001 -5e-11 135.51 -5e-11 \
    135.510001 0 135.55 0 135.550001 -5e-11 135.56 -5e-11 \
    135.560001 0 135.6 0 135.600001 -5e-11 135.61 -5e-11 \
    135.610001 0 135.65 0 135.650001 -5e-11 135.66 -5e-11 \
    135.660001 0 135.7 0 135.700001 -5e-11 135.71 -5e-11 \
    135.710001 0 135.75 0 135.750001 -5e-11 135.76 -5e-11 \
    135.760001 0 135.8 0 135.800001 -5e-11 135.81 -5e-11 \
    135.810001 0 135.85 0 135.850001 -5e-11 135.86 -5e-11 \
    135.860001 0 135.9 0 135.900001 -5e-11 135.91 -5e-11 \
    135.910001 0 135.95 0 135.950001 -5e-11 135.96 -5e-11 \
    135.960001 0 136 0 136.000001 -5e-11 136.01 -5e-11 \
    136.010001 0 136.05 0 136.050001 -5e-11 136.06 -5e-11 \
    136.060001 0 136.1 0 136.100001 -5e-11 136.11 -5e-11 \
    136.110001 0 136.15 0 136.150001 -5e-11 136.16 -5e-11 \
    136.160001 0 136.2 0 136.200001 -5e-11 136.21 -5e-11 \
    136.210001 0 136.25 0 136.250001 -5e-11 136.26 -5e-11 \
    136.260001 0 136.3 0 136.300001 -5e-11 136.31 -5e-11 \
    136.310001 0 136.35 0 136.350001 -5e-11 136.36 -5e-11 \
    136.360001 0 136.4 0 136.400001 -5e-11 136.41 -5e-11 \
    136.410001 0 136.45 0 136.450001 -5e-11 136.46 -5e-11 \
    136.460001 0 136.5 0 136.500001 -5e-11 136.51 -5e-11 \
    136.510001 0 136.55 0 136.550001 -5e-11 136.56 -5e-11 \
    136.560001 0 136.6 0 136.600001 -5e-11 136.61 -5e-11 \
    136.610001 0 136.65 0 136.650001 -5e-11 136.66 -5e-11 \
    136.660001 0 136.7 0 136.700001 -5e-11 136.71 -5e-11 \
    136.710001 0 136.75 0 136.750001 -5e-11 136.76 -5e-11 \
    136.760001 0 136.8 0 136.800001 -5e-11 136.81 -5e-11 \
    136.810001 0 136.85 0 136.850001 -5e-11 136.86 -5e-11 \
    136.860001 0 136.9 0 136.900001 -5e-11 136.91 -5e-11 \
    136.910001 0 136.95 0 136.950001 -5e-11 136.96 -5e-11 \
    136.960001 0 137 0 137.000001 -5e-11 137.01 -5e-11 \
    137.010001 0 137.05 0 137.050001 -5e-11 137.06 -5e-11 \
    137.060001 0 137.1 0 137.100001 -5e-11 137.11 -5e-11 \
    137.110001 0 137.15 0 137.150001 -5e-11 137.16 -5e-11 \
    137.160001 0 137.2 0 137.200001 -5e-11 137.21 -5e-11 \
    137.210001 0 137.25 0 137.250001 -5e-11 137.26 -5e-11 \
    137.260001 0 137.3 0 137.300001 -5e-11 137.31 -5e-11 \
    137.310001 0 137.35 0 137.350001 -5e-11 137.36 -5e-11 \
    137.360001 0 137.4 0 137.400001 -5e-11 137.41 -5e-11 \
    137.410001 0 137.45 0 137.450001 -5e-11 137.46 -5e-11 \
    137.460001 0 137.5 0 137.500001 -5e-11 137.51 -5e-11 \
    137.510001 0 137.55 0 137.550001 -5e-11 137.56 -5e-11 \
    137.560001 0 137.6 0 137.600001 -5e-11 137.61 -5e-11 \
    137.610001 0 137.65 0 137.650001 -5e-11 137.66 -5e-11 \
    137.660001 0 137.7 0 137.700001 -5e-11 137.71 -5e-11 \
    137.710001 0 137.75 0 137.750001 -5e-11 137.76 -5e-11 \
    137.760001 0 137.8 0 137.800001 -5e-11 137.81 -5e-11 \
    137.810001 0 137.85 0 137.850001 -5e-11 137.86 -5e-11 \
    137.860001 0 137.9 0 137.900001 -5e-11 137.91 -5e-11 \
    137.910001 0 137.95 0 137.950001 -5e-11 137.96 -5e-11 \
    137.960001 0 138 0 138.000001 -5e-11 138.01 -5e-11 \
    138.010001 0 138.05 0 138.050001 -5e-11 138.06 -5e-11 \
    138.060001 0 138.1 0 138.100001 -5e-11 138.11 -5e-11 \
    138.110001 0 138.15 0 138.150001 -5e-11 138.16 -5e-11 \
    138.160001 0 138.2 0 138.200001 -5e-11 138.21 -5e-11 \
    138.210001 0 138.25 0 138.250001 -5e-11 138.26 -5e-11 \
    138.260001 0 138.3 0 138.300001 -5e-11 138.31 -5e-11 \
    138.310001 0 138.35 0 138.350001 -5e-11 138.36 -5e-11 \
    138.360001 0 138.4 0 138.400001 -5e-11 138.41 -5e-11 \
    138.410001 0 138.45 0 138.450001 -5e-11 138.46 -5e-11 \
    138.460001 0 138.5 0 138.500001 -5e-11 138.51 -5e-11 \
    138.510001 0 138.55 0 138.550001 -5e-11 138.56 -5e-11 \
    138.560001 0 138.6 0 138.600001 -5e-11 138.61 -5e-11 \
    138.610001 0 138.65 0 138.650001 -5e-11 138.66 -5e-11 \
    138.660001 0 138.7 0 138.700001 -5e-11 138.71 -5e-11 \
    138.710001 0 138.75 0 138.750001 -5e-11 138.76 -5e-11 \
    138.760001 0 138.8 0 138.800001 -5e-11 138.81 -5e-11 \
    138.810001 0 138.85 0 138.850001 -5e-11 138.86 -5e-11 \
    138.860001 0 138.9 0 138.900001 -5e-11 138.91 -5e-11 \
    138.910001 0 138.95 0 138.950001 -5e-11 138.96 -5e-11 \
    138.960001 0 139 0 139.000001 -5e-11 139.01 -5e-11 \
    139.010001 0 139.05 0 139.050001 -5e-11 139.06 -5e-11 \
    139.060001 0 139.1 0 139.100001 -5e-11 139.11 -5e-11 \
    139.110001 0 139.15 0 139.150001 -5e-11 139.16 -5e-11 \
    139.160001 0 139.2 0 139.200001 -5e-11 139.21 -5e-11 \
    139.210001 0 139.25 0 139.250001 -5e-11 139.26 -5e-11 \
    139.260001 0 139.3 0 139.300001 -5e-11 139.31 -5e-11 \
    139.310001 0 139.35 0 139.350001 -5e-11 139.36 -5e-11 \
    139.360001 0 139.4 0 139.400001 -5e-11 139.41 -5e-11 \
    139.410001 0 139.45 0 139.450001 -5e-11 139.46 -5e-11 \
    139.460001 0 139.5 0 139.500001 -5e-11 139.51 -5e-11 \
    139.510001 0 139.55 0 139.550001 -5e-11 139.56 -5e-11 \
    139.560001 0 139.6 0 139.600001 -5e-11 139.61 -5e-11 \
    139.610001 0 139.65 0 139.650001 -5e-11 139.66 -5e-11 \
    139.660001 0 139.7 0 139.700001 -5e-11 139.71 -5e-11 \
    139.710001 0 139.75 0 139.750001 -5e-11 139.76 -5e-11 \
    139.760001 0 139.8 0 139.800001 -5e-11 139.81 -5e-11 \
    139.810001 0 139.85 0 139.850001 -5e-11 139.86 -5e-11 \
    139.860001 0 139.9 0 139.900001 -5e-11 139.91 -5e-11 \
    139.910001 0 139.95 0 139.950001 -5e-11 139.96 -5e-11 \
    139.960001 0 140 0 140.000001 -5e-11 140.01 -5e-11 \
    140.010001 0 140.05 0 140.050001 -5e-11 140.06 -5e-11 \
    140.060001 0 140.1 0 140.100001 -5e-11 140.11 -5e-11 \
    140.110001 0 140.15 0 140.150001 -5e-11 140.16 -5e-11 \
    140.160001 0 140.2 0 140.200001 -5e-11 140.21 -5e-11 \
    140.210001 0 140.25 0 140.250001 -5e-11 140.26 -5e-11 \
    140.260001 0 140.3 0 140.300001 -5e-11 140.31 -5e-11 \
    140.310001 0 140.35 0 140.350001 -5e-11 140.36 -5e-11 \
    140.360001 0 140.4 0 140.400001 -5e-11 140.41 -5e-11 \
    140.410001 0 140.45 0 140.450001 -5e-11 140.46 -5e-11 \
    140.460001 0 140.5 0 140.500001 -5e-11 140.51 -5e-11 \
    140.510001 0 140.55 0 140.550001 -5e-11 140.56 -5e-11 \
    140.560001 0 140.6 0 140.600001 -5e-11 140.61 -5e-11 \
    140.610001 0 140.65 0 140.650001 -5e-11 140.66 -5e-11 \
    140.660001 0 140.7 0 140.700001 -5e-11 140.71 -5e-11 \
    140.710001 0 140.75 0 140.750001 -5e-11 140.76 -5e-11 \
    140.760001 0 140.8 0 140.800001 -5e-11 140.81 -5e-11 \
    140.810001 0 140.85 0 140.850001 -5e-11 140.86 -5e-11 \
    140.860001 0 140.9 0 140.900001 -5e-11 140.91 -5e-11 \
    140.910001 0 140.95 0 140.950001 -5e-11 140.96 -5e-11 \
    140.960001 0 141 0 141.000001 -5e-11 141.01 -5e-11 \
    141.010001 0 141.05 0 141.050001 -5e-11 141.06 -5e-11 \
    141.060001 0 141.1 0 141.100001 -5e-11 141.11 -5e-11 \
    141.110001 0 141.15 0 141.150001 -5e-11 141.16 -5e-11 \
    141.160001 0 141.2 0 141.200001 -5e-11 141.21 -5e-11 \
    141.210001 0 141.25 0 141.250001 -5e-11 141.26 -5e-11 \
    141.260001 0 141.3 0 141.300001 -5e-11 141.31 -5e-11 \
    141.310001 0 141.35 0 141.350001 -5e-11 141.36 -5e-11 \
    141.360001 0 141.4 0 141.400001 -5e-11 141.41 -5e-11 \
    141.410001 0 141.45 0 141.450001 -5e-11 141.46 -5e-11 \
    141.460001 0 141.5 0 141.500001 -5e-11 141.51 -5e-11 \
    141.510001 0 141.55 0 141.550001 -5e-11 141.56 -5e-11 \
    141.560001 0 141.6 0 141.600001 -5e-11 141.61 -5e-11 \
    141.610001 0 141.65 0 141.650001 -5e-11 141.66 -5e-11 \
    141.660001 0 141.7 0 141.700001 -5e-11 141.71 -5e-11 \
    141.710001 0 141.75 0 141.750001 -5e-11 141.76 -5e-11 \
    141.760001 0 141.8 0 141.800001 -5e-11 141.81 -5e-11 \
    141.810001 0 141.85 0 141.850001 -5e-11 141.86 -5e-11 \
    141.860001 0 141.9 0 141.900001 -5e-11 141.91 -5e-11 \
    141.910001 0 141.95 0 141.950001 -5e-11 141.96 -5e-11 \
    141.960001 0 142 0 142.000001 -5e-11 142.01 -5e-11 \
    142.010001 0 142.05 0 142.050001 -5e-11 142.06 -5e-11 \
    142.060001 0 142.1 0 142.100001 -5e-11 142.11 -5e-11 \
    142.110001 0 142.15 0 142.150001 -5e-11 142.16 -5e-11 \
    142.160001 0 142.2 0 142.200001 -5e-11 142.21 -5e-11 \
    142.210001 0 142.25 0 142.250001 -5e-11 142.26 -5e-11 \
    142.260001 0 142.3 0 142.300001 -5e-11 142.31 -5e-11 \
    142.310001 0 142.35 0 142.350001 -5e-11 142.36 -5e-11 \
    142.360001 0 142.4 0 142.400001 -5e-11 142.41 -5e-11 \
    142.410001 0 142.45 0 142.450001 -5e-11 142.46 -5e-11 \
    142.460001 0 142.5 0 142.500001 -5e-11 142.51 -5e-11 \
    142.510001 0 142.55 0 142.550001 -5e-11 142.56 -5e-11 \
    142.560001 0 142.6 0 142.600001 -5e-11 142.61 -5e-11 \
    142.610001 0 142.65 0 142.650001 -5e-11 142.66 -5e-11 \
    142.660001 0 142.7 0 142.700001 -5e-11 142.71 -5e-11 \
    142.710001 0 142.75 0 142.750001 -5e-11 142.76 -5e-11 \
    142.760001 0 142.8 0 142.800001 -5e-11 142.81 -5e-11 \
    142.810001 0 142.85 0 142.850001 -5e-11 142.86 -5e-11 \
    142.860001 0 142.9 0 142.900001 -5e-11 142.91 -5e-11 \
    142.910001 0 142.95 0 142.950001 -5e-11 142.96 -5e-11 \
    142.960001 0 143 0 143.000001 -5e-11 143.01 -5e-11 \
    143.010001 0 143.05 0 143.050001 -5e-11 143.06 -5e-11 \
    143.060001 0 143.1 0 143.100001 -5e-11 143.11 -5e-11 \
    143.110001 0 143.15 0 143.150001 -5e-11 143.16 -5e-11 \
    143.160001 0 143.2 0 143.200001 -5e-11 143.21 -5e-11 \
    143.210001 0 143.25 0 143.250001 -5e-11 143.26 -5e-11 \
    143.260001 0 143.3 0 143.300001 -5e-11 143.31 -5e-11 \
    143.310001 0 143.35 0 143.350001 -5e-11 143.36 -5e-11 \
    143.360001 0 143.4 0 143.400001 -5e-11 143.41 -5e-11 \
    143.410001 0 143.45 0 143.450001 -5e-11 143.46 -5e-11 \
    143.460001 0 143.5 0 143.500001 -5e-11 143.51 -5e-11 \
    143.510001 0 143.55 0 143.550001 -5e-11 143.56 -5e-11 \
    143.560001 0 143.6 0 143.600001 -5e-11 143.61 -5e-11 \
    143.610001 0 143.65 0 143.650001 -5e-11 143.66 -5e-11 \
    143.660001 0 143.7 0 143.700001 -5e-11 143.71 -5e-11 \
    143.710001 0 143.75 0 143.750001 -5e-11 143.76 -5e-11 \
    143.760001 0 143.8 0 143.800001 -5e-11 143.81 -5e-11 \
    143.810001 0 143.85 0 143.850001 -5e-11 143.86 -5e-11 \
    143.860001 0 143.9 0 143.900001 -5e-11 143.91 -5e-11 \
    143.910001 0 143.95 0 143.950001 -5e-11 143.96 -5e-11 \
    143.960001 0 144 0 144.000001 -5e-11 144.01 -5e-11 \
    144.010001 0 144.05 0 144.050001 -5e-11 144.06 -5e-11 \
    144.060001 0 144.1 0 144.100001 -5e-11 144.11 -5e-11 \
    144.110001 0 144.15 0 144.150001 -5e-11 144.16 -5e-11 \
    144.160001 0 144.2 0 144.200001 -5e-11 144.21 -5e-11 \
    144.210001 0 144.25 0 144.250001 -5e-11 144.26 -5e-11 \
    144.260001 0 144.3 0 144.300001 -5e-11 144.31 -5e-11 \
    144.310001 0 144.35 0 144.350001 -5e-11 144.36 -5e-11 \
    144.360001 0 144.4 0 144.400001 -5e-11 144.41 -5e-11 \
    144.410001 0 144.45 0 144.450001 -5e-11 144.46 -5e-11 \
    144.460001 0 144.5 0 144.500001 -5e-11 144.51 -5e-11 \
    144.510001 0 144.55 0 144.550001 -5e-11 144.56 -5e-11 \
    144.560001 0 144.6 0 144.600001 -5e-11 144.61 -5e-11 \
    144.610001 0 144.65 0 144.650001 -5e-11 144.66 -5e-11 \
    144.660001 0 144.7 0 144.700001 -5e-11 144.71 -5e-11 \
    144.710001 0 144.75 0 144.750001 -5e-11 144.76 -5e-11 \
    144.760001 0 144.8 0 144.800001 -5e-11 144.81 -5e-11 \
    144.810001 0 144.85 0 144.850001 -5e-11 144.86 -5e-11 \
    144.860001 0 144.9 0 144.900001 -5e-11 144.91 -5e-11 \
    144.910001 0 144.95 0 144.950001 -5e-11 144.96 -5e-11 \
    144.960001 0 145 0 145.000001 -5e-11 145.01 -5e-11 \
    145.010001 0 145.05 0 145.050001 -5e-11 145.06 -5e-11 \
    145.060001 0 145.1 0 145.100001 -5e-11 145.11 -5e-11 \
    145.110001 0 145.15 0 145.150001 -5e-11 145.16 -5e-11 \
    145.160001 0 145.2 0 145.200001 -5e-11 145.21 -5e-11 \
    145.210001 0 145.25 0 145.250001 -5e-11 145.26 -5e-11 \
    145.260001 0 145.3 0 145.300001 -5e-11 145.31 -5e-11 \
    145.310001 0 145.35 0 145.350001 -5e-11 145.36 -5e-11 \
    145.360001 0 145.4 0 145.400001 -5e-11 145.41 -5e-11 \
    145.410001 0 145.45 0 145.450001 -5e-11 145.46 -5e-11 \
    145.460001 0 145.5 0 145.500001 -5e-11 145.51 -5e-11 \
    145.510001 0 145.55 0 145.550001 -5e-11 145.56 -5e-11 \
    145.560001 0 145.6 0 145.600001 -5e-11 145.61 -5e-11 \
    145.610001 0 145.65 0 145.650001 -5e-11 145.66 -5e-11 \
    145.660001 0 145.7 0 145.700001 -5e-11 145.71 -5e-11 \
    145.710001 0 145.75 0 145.750001 -5e-11 145.76 -5e-11 \
    145.760001 0 145.8 0 145.800001 -5e-11 145.81 -5e-11 \
    145.810001 0 145.85 0 145.850001 -5e-11 145.86 -5e-11 \
    145.860001 0 145.9 0 145.900001 -5e-11 145.91 -5e-11 \
    145.910001 0 145.95 0 145.950001 -5e-11 145.96 -5e-11 \
    145.960001 0 146 0 146.000001 -5e-11 146.01 -5e-11 \
    146.010001 0 146.05 0 146.050001 -5e-11 146.06 -5e-11 \
    146.060001 0 146.1 0 146.100001 -5e-11 146.11 -5e-11 \
    146.110001 0 146.15 0 146.150001 -5e-11 146.16 -5e-11 \
    146.160001 0 146.2 0 146.200001 -5e-11 146.21 -5e-11 \
    146.210001 0 146.25 0 146.250001 -5e-11 146.26 -5e-11 \
    146.260001 0 146.3 0 146.300001 -5e-11 146.31 -5e-11 \
    146.310001 0 146.35 0 146.350001 -5e-11 146.36 -5e-11 \
    146.360001 0 146.4 0 146.400001 -5e-11 146.41 -5e-11 \
    146.410001 0 146.45 0 146.450001 -5e-11 146.46 -5e-11 \
    146.460001 0 146.5 0 146.500001 -5e-11 146.51 -5e-11 \
    146.510001 0 146.55 0 146.550001 -5e-11 146.56 -5e-11 \
    146.560001 0 146.6 0 146.600001 -5e-11 146.61 -5e-11 \
    146.610001 0 146.65 0 146.650001 -5e-11 146.66 -5e-11 \
    146.660001 0 146.7 0 146.700001 -5e-11 146.71 -5e-11 \
    146.710001 0 146.75 0 146.750001 -5e-11 146.76 -5e-11 \
    146.760001 0 146.8 0 146.800001 -5e-11 146.81 -5e-11 \
    146.810001 0 146.85 0 146.850001 -5e-11 146.86 -5e-11 \
    146.860001 0 146.9 0 146.900001 -5e-11 146.91 -5e-11 \
    146.910001 0 146.95 0 146.950001 -5e-11 146.96 -5e-11 \
    146.960001 0 147 0 147.000001 -5e-11 147.01 -5e-11 \
    147.010001 0 147.05 0 147.050001 -5e-11 147.06 -5e-11 \
    147.060001 0 147.1 0 147.100001 -5e-11 147.11 -5e-11 \
    147.110001 0 147.15 0 147.150001 -5e-11 147.16 -5e-11 \
    147.160001 0 147.2 0 147.200001 -5e-11 147.21 -5e-11 \
    147.210001 0 147.25 0 147.250001 -5e-11 147.26 -5e-11 \
    147.260001 0 147.3 0 147.300001 -5e-11 147.31 -5e-11 \
    147.310001 0 147.35 0 147.350001 -5e-11 147.36 -5e-11 \
    147.360001 0 147.4 0 147.400001 -5e-11 147.41 -5e-11 \
    147.410001 0 147.45 0 147.450001 -5e-11 147.46 -5e-11 \
    147.460001 0 147.5 0 147.500001 -5e-11 147.51 -5e-11 \
    147.510001 0 147.55 0 147.550001 -5e-11 147.56 -5e-11 \
    147.560001 0 147.6 0 147.600001 -5e-11 147.61 -5e-11 \
    147.610001 0 147.65 0 147.650001 -5e-11 147.66 -5e-11 \
    147.660001 0 147.7 0 147.700001 -5e-11 147.71 -5e-11 \
    147.710001 0 147.75 0 147.750001 -5e-11 147.76 -5e-11 \
    147.760001 0 147.8 0 147.800001 -5e-11 147.81 -5e-11 \
    147.810001 0 147.85 0 147.850001 -5e-11 147.86 -5e-11 \
    147.860001 0 147.9 0 147.900001 -5e-11 147.91 -5e-11 \
    147.910001 0 147.95 0 147.950001 -5e-11 147.96 -5e-11 \
    147.960001 0 148 0 148.000001 -5e-11 148.01 -5e-11 \
    148.010001 0 148.05 0 148.050001 -5e-11 148.06 -5e-11 \
    148.060001 0 148.1 0 148.100001 -5e-11 148.11 -5e-11 \
    148.110001 0 148.15 0 148.150001 -5e-11 148.16 -5e-11 \
    148.160001 0 148.2 0 148.200001 -5e-11 148.21 -5e-11 \
    148.210001 0 148.25 0 148.250001 -5e-11 148.26 -5e-11 \
    148.260001 0 148.3 0 148.300001 -5e-11 148.31 -5e-11 \
    148.310001 0 148.35 0 148.350001 -5e-11 148.36 -5e-11 \
    148.360001 0 148.4 0 148.400001 -5e-11 148.41 -5e-11 \
    148.410001 0 148.45 0 148.450001 -5e-11 148.46 -5e-11 \
    148.460001 0 148.5 0 148.500001 -5e-11 148.51 -5e-11 \
    148.510001 0 148.55 0 148.550001 -5e-11 148.56 -5e-11 \
    148.560001 0 148.6 0 148.600001 -5e-11 148.61 -5e-11 \
    148.610001 0 148.65 0 148.650001 -5e-11 148.66 -5e-11 \
    148.660001 0 148.7 0 148.700001 -5e-11 148.71 -5e-11 \
    148.710001 0 148.75 0 148.750001 -5e-11 148.76 -5e-11 \
    148.760001 0 148.8 0 148.800001 -5e-11 148.81 -5e-11 \
    148.810001 0 148.85 0 148.850001 -5e-11 148.86 -5e-11 \
    148.860001 0 148.9 0 148.900001 -5e-11 148.91 -5e-11 \
    148.910001 0 148.95 0 148.950001 -5e-11 148.96 -5e-11 \
    148.960001 0 149 0 149.000001 -5e-11 149.01 -5e-11 \
    149.010001 0 149.05 0 149.050001 -5e-11 149.06 -5e-11 \
    149.060001 0 149.1 0 149.100001 -5e-11 149.11 -5e-11 \
    149.110001 0 149.15 0 149.150001 -5e-11 149.16 -5e-11 \
    149.160001 0 149.2 0 149.200001 -5e-11 149.21 -5e-11 \
    149.210001 0 149.25 0 149.250001 -5e-11 149.26 -5e-11 \
    149.260001 0 149.3 0 149.300001 -5e-11 149.31 -5e-11 \
    149.310001 0 149.35 0 149.350001 -5e-11 149.36 -5e-11 \
    149.360001 0 149.4 0 149.400001 -5e-11 149.41 -5e-11 \
    149.410001 0 149.45 0 149.450001 -5e-11 149.46 -5e-11 \
    149.460001 0 149.5 0 149.500001 -5e-11 149.51 -5e-11 \
    149.510001 0 149.55 0 149.550001 -5e-11 149.56 -5e-11 \
    149.560001 0 149.6 0 149.600001 -5e-11 149.61 -5e-11 \
    149.610001 0 149.65 0 149.650001 -5e-11 149.66 -5e-11 \
    149.660001 0 149.7 0 149.700001 -5e-11 149.71 -5e-11 \
    149.710001 0 149.75 0 149.750001 -5e-11 149.76 -5e-11 \
    149.760001 0 149.8 0 149.800001 -5e-11 149.81 -5e-11 \
    149.810001 0 149.85 0 149.850001 -5e-11 149.86 -5e-11 \
    149.860001 0 149.9 0 149.900001 -5e-11 149.91 -5e-11 \
    149.910001 0 149.95 0 149.950001 -5e-11 149.96 -5e-11 \
    149.960001 0 150 0 150.000001 -5e-11 150.01 -5e-11 \
    150.010001 0 150.05 0 150.050001 -5e-11 150.06 -5e-11 \
    150.060001 0 150.1 0 150.100001 -5e-11 150.11 -5e-11 \
    150.110001 0 150.15 0 150.150001 -5e-11 150.16 -5e-11 \
    150.160001 0 150.2 0 150.200001 -5e-11 150.21 -5e-11 \
    150.210001 0 150.25 0 150.250001 -5e-11 150.26 -5e-11 \
    150.260001 0 150.3 0 150.300001 -5e-11 150.31 -5e-11 \
    150.310001 0 150.35 0 150.350001 -5e-11 150.36 -5e-11 \
    150.360001 0 150.4 0 150.400001 -5e-11 150.41 -5e-11 \
    150.410001 0 150.45 0 150.450001 -5e-11 150.46 -5e-11 \
    150.460001 0 150.5 0 150.500001 -5e-11 150.51 -5e-11 \
    150.510001 0 150.55 0 150.550001 -5e-11 150.56 -5e-11 \
    150.560001 0 150.6 0 150.600001 -5e-11 150.61 -5e-11 \
    150.610001 0 150.65 0 150.650001 -5e-11 150.66 -5e-11 \
    150.660001 0 150.7 0 150.700001 -5e-11 150.71 -5e-11 \
    150.710001 0 150.75 0 150.750001 -5e-11 150.76 -5e-11 \
    150.760001 0 150.8 0 150.800001 -5e-11 150.81 -5e-11 \
    150.810001 0 150.85 0 150.850001 -5e-11 150.86 -5e-11 \
    150.860001 0 150.9 0 150.900001 -5e-11 150.91 -5e-11 \
    150.910001 0 150.95 0 150.950001 -5e-11 150.96 -5e-11 \
    150.960001 0 151 0 151.000001 -5e-11 151.01 -5e-11 \
    151.010001 0 151.05 0 151.050001 -5e-11 151.06 -5e-11 \
    151.060001 0 151.1 0 151.100001 -5e-11 151.11 -5e-11 \
    151.110001 0 151.15 0 151.150001 -5e-11 151.16 -5e-11 \
    151.160001 0 151.2 0 151.200001 -5e-11 151.21 -5e-11 \
    151.210001 0 151.25 0 151.250001 -5e-11 151.26 -5e-11 \
    151.260001 0 151.3 0 151.300001 -5e-11 151.31 -5e-11 \
    151.310001 0 151.35 0 151.350001 -5e-11 151.36 -5e-11 \
    151.360001 0 151.4 0 151.400001 -5e-11 151.41 -5e-11 \
    151.410001 0 151.45 0 151.450001 -5e-11 151.46 -5e-11 \
    151.460001 0 151.5 0 151.500001 -5e-11 151.51 -5e-11 \
    151.510001 0 151.55 0 151.550001 -5e-11 151.56 -5e-11 \
    151.560001 0 151.6 0 151.600001 -5e-11 151.61 -5e-11 \
    151.610001 0 151.65 0 151.650001 -5e-11 151.66 -5e-11 \
    151.660001 0 151.7 0 151.700001 -5e-11 151.71 -5e-11 \
    151.710001 0 151.75 0 151.750001 -5e-11 151.76 -5e-11 \
    151.760001 0 151.8 0 151.800001 -5e-11 151.81 -5e-11 \
    151.810001 0 151.85 0 151.850001 -5e-11 151.86 -5e-11 \
    151.860001 0 151.9 0 151.900001 -5e-11 151.91 -5e-11 \
    151.910001 0 151.95 0 151.950001 -5e-11 151.96 -5e-11 \
    151.960001 0 152 0 152.000001 -5e-11 152.01 -5e-11 \
    152.010001 0 152.05 0 152.050001 -5e-11 152.06 -5e-11 \
    152.060001 0 152.1 0 152.100001 -5e-11 152.11 -5e-11 \
    152.110001 0 152.15 0 152.150001 -5e-11 152.16 -5e-11 \
    152.160001 0 152.2 0 152.200001 -5e-11 152.21 -5e-11 \
    152.210001 0 152.25 0 152.250001 -5e-11 152.26 -5e-11 \
    152.260001 0 152.3 0 152.300001 -5e-11 152.31 -5e-11 \
    152.310001 0 152.35 0 152.350001 -5e-11 152.36 -5e-11 \
    152.360001 0 152.4 0 152.400001 -5e-11 152.41 -5e-11 \
    152.410001 0 152.45 0 152.450001 -5e-11 152.46 -5e-11 \
    152.460001 0 152.5 0 152.500001 -5e-11 152.51 -5e-11 \
    152.510001 0 152.55 0 152.550001 -5e-11 152.56 -5e-11 \
    152.560001 0 152.6 0 152.600001 -5e-11 152.61 -5e-11 \
    152.610001 0 152.65 0 152.650001 -5e-11 152.66 -5e-11 \
    152.660001 0 152.7 0 152.700001 -5e-11 152.71 -5e-11 \
    152.710001 0 152.75 0 152.750001 -5e-11 152.76 -5e-11 \
    152.760001 0 152.8 0 152.800001 -5e-11 152.81 -5e-11 \
    152.810001 0 152.85 0 152.850001 -5e-11 152.86 -5e-11 \
    152.860001 0 152.9 0 152.900001 -5e-11 152.91 -5e-11 \
    152.910001 0 152.95 0 152.950001 -5e-11 152.96 -5e-11 \
    152.960001 0 153 0 153.000001 -5e-11 153.01 -5e-11 \
    153.010001 0 153.05 0 153.050001 -5e-11 153.06 -5e-11 \
    153.060001 0 153.1 0 153.100001 -5e-11 153.11 -5e-11 \
    153.110001 0 153.15 0 153.150001 -5e-11 153.16 -5e-11 \
    153.160001 0 153.2 0 153.200001 -5e-11 153.21 -5e-11 \
    153.210001 0 153.25 0 153.250001 -5e-11 153.26 -5e-11 \
    153.260001 0 153.3 0 153.300001 -5e-11 153.31 -5e-11 \
    153.310001 0 153.35 0 153.350001 -5e-11 153.36 -5e-11 \
    153.360001 0 153.4 0 153.400001 -5e-11 153.41 -5e-11 \
    153.410001 0 153.45 0 153.450001 -5e-11 153.46 -5e-11 \
    153.460001 0 153.5 0 153.500001 -5e-11 153.51 -5e-11 \
    153.510001 0 153.55 0 153.550001 -5e-11 153.56 -5e-11 \
    153.560001 0 153.6 0 153.600001 -5e-11 153.61 -5e-11 \
    153.610001 0 153.65 0 153.650001 -5e-11 153.66 -5e-11 \
    153.660001 0 153.7 0 153.700001 -5e-11 153.71 -5e-11 \
    153.710001 0 153.75 0 153.750001 -5e-11 153.76 -5e-11 \
    153.760001 0 153.8 0 153.800001 -5e-11 153.81 -5e-11 \
    153.810001 0 153.85 0 153.850001 -5e-11 153.86 -5e-11 \
    153.860001 0 153.9 0 153.900001 -5e-11 153.91 -5e-11 \
    153.910001 0 153.95 0 153.950001 -5e-11 153.96 -5e-11 \
    153.960001 0 154 0 154.000001 -5e-11 154.01 -5e-11 \
    154.010001 0 154.05 0 154.050001 -5e-11 154.06 -5e-11 \
    154.060001 0 154.1 0 154.100001 -5e-11 154.11 -5e-11 \
    154.110001 0 154.15 0 154.150001 -5e-11 154.16 -5e-11 \
    154.160001 0 154.2 0 154.200001 -5e-11 154.21 -5e-11 \
    154.210001 0 154.25 0 154.250001 -5e-11 154.26 -5e-11 \
    154.260001 0 154.3 0 154.300001 -5e-11 154.31 -5e-11 \
    154.310001 0 154.35 0 154.350001 -5e-11 154.36 -5e-11 \
    154.360001 0 154.4 0 154.400001 -5e-11 154.41 -5e-11 \
    154.410001 0 154.45 0 154.450001 -5e-11 154.46 -5e-11 \
    154.460001 0 154.5 0 154.500001 -5e-11 154.51 -5e-11 \
    154.510001 0 154.55 0 154.550001 -5e-11 154.56 -5e-11 \
    154.560001 0 154.6 0 154.600001 -5e-11 154.61 -5e-11 \
    154.610001 0 154.65 0 154.650001 -5e-11 154.66 -5e-11 \
    154.660001 0 154.7 0 154.700001 -5e-11 154.71 -5e-11 \
    154.710001 0 154.75 0 154.750001 -5e-11 154.76 -5e-11 \
    154.760001 0 154.8 0 154.800001 -5e-11 154.81 -5e-11 \
    154.810001 0 154.85 0 154.850001 -5e-11 154.86 -5e-11 \
    154.860001 0 154.9 0 154.900001 -5e-11 154.91 -5e-11 \
    154.910001 0 154.95 0 154.950001 -5e-11 154.96 -5e-11 \
    154.960001 0 155 0 155.000001 -5e-11 155.01 -5e-11 \
    155.010001 0 155.05 0 155.050001 -5e-11 155.06 -5e-11 \
    155.060001 0 155.1 0 155.100001 -5e-11 155.11 -5e-11 \
    155.110001 0 155.15 0 155.150001 -5e-11 155.16 -5e-11 \
    155.160001 0 155.2 0 155.200001 -5e-11 155.21 -5e-11 \
    155.210001 0 155.25 0 155.250001 -5e-11 155.26 -5e-11 \
    155.260001 0 155.3 0 155.300001 -5e-11 155.31 -5e-11 \
    155.310001 0 155.35 0 155.350001 -5e-11 155.36 -5e-11 \
    155.360001 0 155.4 0 155.400001 -5e-11 155.41 -5e-11 \
    155.410001 0 155.45 0 155.450001 -5e-11 155.46 -5e-11 \
    155.460001 0 155.5 0 155.500001 -5e-11 155.51 -5e-11 \
    155.510001 0 155.55 0 155.550001 -5e-11 155.56 -5e-11 \
    155.560001 0 155.6 0 155.600001 -5e-11 155.61 -5e-11 \
    155.610001 0 155.65 0 155.650001 -5e-11 155.66 -5e-11 \
    155.660001 0 155.7 0 155.700001 -5e-11 155.71 -5e-11 \
    155.710001 0 155.75 0 155.750001 -5e-11 155.76 -5e-11 \
    155.760001 0 155.8 0 155.800001 -5e-11 155.81 -5e-11 \
    155.810001 0 155.85 0 155.850001 -5e-11 155.86 -5e-11 \
    155.860001 0 155.9 0 155.900001 -5e-11 155.91 -5e-11 \
    155.910001 0 155.95 0 155.950001 -5e-11 155.96 -5e-11 \
    155.960001 0 156 0 156.000001 -5e-11 156.01 -5e-11 \
    156.010001 0 156.05 0 156.050001 -5e-11 156.06 -5e-11 \
    156.060001 0 156.1 0 156.100001 -5e-11 156.11 -5e-11 \
    156.110001 0 156.15 0 156.150001 -5e-11 156.16 -5e-11 \
    156.160001 0 156.2 0 156.200001 -5e-11 156.21 -5e-11 \
    156.210001 0 156.25 0 156.250001 -5e-11 156.26 -5e-11 \
    156.260001 0 156.3 0 156.300001 -5e-11 156.31 -5e-11 \
    156.310001 0 156.35 0 156.350001 -5e-11 156.36 -5e-11 \
    156.360001 0 156.4 0 156.400001 -5e-11 156.41 -5e-11 \
    156.410001 0 156.45 0 156.450001 -5e-11 156.46 -5e-11 \
    156.460001 0 156.5 0 156.500001 -5e-11 156.51 -5e-11 \
    156.510001 0 156.55 0 156.550001 -5e-11 156.56 -5e-11 \
    156.560001 0 156.6 0 156.600001 -5e-11 156.61 -5e-11 \
    156.610001 0 156.65 0 156.650001 -5e-11 156.66 -5e-11 \
    156.660001 0 156.7 0 156.700001 -5e-11 156.71 -5e-11 \
    156.710001 0 156.75 0 156.750001 -5e-11 156.76 -5e-11 \
    156.760001 0 156.8 0 156.800001 -5e-11 156.81 -5e-11 \
    156.810001 0 156.85 0 156.850001 -5e-11 156.86 -5e-11 \
    156.860001 0 156.9 0 156.900001 -5e-11 156.91 -5e-11 \
    156.910001 0 156.95 0 156.950001 -5e-11 156.96 -5e-11 \
    156.960001 0 157 0 157.000001 -5e-11 157.01 -5e-11 \
    157.010001 0 157.05 0 157.050001 -5e-11 157.06 -5e-11 \
    157.060001 0 157.1 0 157.100001 -5e-11 157.11 -5e-11 \
    157.110001 0 157.15 0 157.150001 -5e-11 157.16 -5e-11 \
    157.160001 0 157.2 0 157.200001 -5e-11 157.21 -5e-11 \
    157.210001 0 157.25 0 157.250001 -5e-11 157.26 -5e-11 \
    157.260001 0 157.3 0 157.300001 -5e-11 157.31 -5e-11 \
    157.310001 0 157.35 0 157.350001 -5e-11 157.36 -5e-11 \
    157.360001 0 157.4 0 157.400001 -5e-11 157.41 -5e-11 \
    157.410001 0 157.45 0 157.450001 -5e-11 157.46 -5e-11 \
    157.460001 0 157.5 0 157.500001 -5e-11 157.51 -5e-11 \
    157.510001 0 157.55 0 157.550001 -5e-11 157.56 -5e-11 \
    157.560001 0 157.6 0 157.600001 -5e-11 157.61 -5e-11 \
    157.610001 0 157.65 0 157.650001 -5e-11 157.66 -5e-11 \
    157.660001 0 157.7 0 157.700001 -5e-11 157.71 -5e-11 \
    157.710001 0 157.75 0 157.750001 -5e-11 157.76 -5e-11 \
    157.760001 0 157.8 0 157.800001 -5e-11 157.81 -5e-11 \
    157.810001 0 157.85 0 157.850001 -5e-11 157.86 -5e-11 \
    157.860001 0 157.9 0 157.900001 -5e-11 157.91 -5e-11 \
    157.910001 0 157.95 0 157.950001 -5e-11 157.96 -5e-11 \
    157.960001 0 158 0 158.000001 -5e-11 158.01 -5e-11 \
    158.010001 0 158.05 0 158.050001 -5e-11 158.06 -5e-11 \
    158.060001 0 158.1 0 158.100001 -5e-11 158.11 -5e-11 \
    158.110001 0 158.15 0 158.150001 -5e-11 158.16 -5e-11 \
    158.160001 0 158.2 0 158.200001 -5e-11 158.21 -5e-11 \
    158.210001 0 158.25 0 158.250001 -5e-11 158.26 -5e-11 \
    158.260001 0 158.3 0 158.300001 -5e-11 158.31 -5e-11 \
    158.310001 0 158.35 0 158.350001 -5e-11 158.36 -5e-11 \
    158.360001 0 158.4 0 158.400001 -5e-11 158.41 -5e-11 \
    158.410001 0 158.45 0 158.450001 -5e-11 158.46 -5e-11 \
    158.460001 0 158.5 0 158.500001 -5e-11 158.51 -5e-11 \
    158.510001 0 158.55 0 158.550001 -5e-11 158.56 -5e-11 \
    158.560001 0 158.6 0 158.600001 -5e-11 158.61 -5e-11 \
    158.610001 0 158.65 0 158.650001 -5e-11 158.66 -5e-11 \
    158.660001 0 158.7 0 158.700001 -5e-11 158.71 -5e-11 \
    158.710001 0 158.75 0 158.750001 -5e-11 158.76 -5e-11 \
    158.760001 0 158.8 0 158.800001 -5e-11 158.81 -5e-11 \
    158.810001 0 158.85 0 158.850001 -5e-11 158.86 -5e-11 \
    158.860001 0 158.9 0 158.900001 -5e-11 158.91 -5e-11 \
    158.910001 0 158.95 0 158.950001 -5e-11 158.96 -5e-11 \
    158.960001 0 159 0 159.000001 -5e-11 159.01 -5e-11 \
    159.010001 0 159.05 0 159.050001 -5e-11 159.06 -5e-11 \
    159.060001 0 159.1 0 159.100001 -5e-11 159.11 -5e-11 \
    159.110001 0 159.15 0 159.150001 -5e-11 159.16 -5e-11 \
    159.160001 0 159.2 0 159.200001 -5e-11 159.21 -5e-11 \
    159.210001 0 159.25 0 159.250001 -5e-11 159.26 -5e-11 \
    159.260001 0 159.3 0 159.300001 -5e-11 159.31 -5e-11 \
    159.310001 0 159.35 0 159.350001 -5e-11 159.36 -5e-11 \
    159.360001 0 159.4 0 159.400001 -5e-11 159.41 -5e-11 \
    159.410001 0 159.45 0 159.450001 -5e-11 159.46 -5e-11 \
    159.460001 0 159.5 0 159.500001 -5e-11 159.51 -5e-11 \
    159.510001 0 159.55 0 159.550001 -5e-11 159.56 -5e-11 \
    159.560001 0 159.6 0 159.600001 -5e-11 159.61 -5e-11 \
    159.610001 0 159.65 0 159.650001 -5e-11 159.66 -5e-11 \
    159.660001 0 159.7 0 159.700001 -5e-11 159.71 -5e-11 \
    159.710001 0 159.75 0 159.750001 -5e-11 159.76 -5e-11 \
    159.760001 0 159.8 0 159.800001 -5e-11 159.81 -5e-11 \
    159.810001 0 159.85 0 159.850001 -5e-11 159.86 -5e-11 \
    159.860001 0 159.9 0 159.900001 -5e-11 159.91 -5e-11 \
    159.910001 0 159.95 0 159.950001 -5e-11 159.96 -5e-11 \
    159.960001 0 160 0 160.000001 -5e-11 160.01 -5e-11 \
    160.010001 0 160.05 0 160.050001 -5e-11 160.06 -5e-11 \
    160.060001 0 160.1 0 160.100001 -5e-11 160.11 -5e-11 \
    160.110001 0 160.15 0 160.150001 -5e-11 160.16 -5e-11 \
    160.160001 0 160.2 0 160.200001 -5e-11 160.21 -5e-11 \
    160.210001 0 160.25 0 160.250001 -5e-11 160.26 -5e-11 \
    160.260001 0 160.3 0 160.300001 -5e-11 160.31 -5e-11 \
    160.310001 0 160.35 0 160.350001 -5e-11 160.36 -5e-11 \
    160.360001 0 160.4 0 160.400001 -5e-11 160.41 -5e-11 \
    160.410001 0 160.45 0 160.450001 -5e-11 160.46 -5e-11 \
    160.460001 0 160.5 0 160.500001 -5e-11 160.51 -5e-11 \
    160.510001 0 160.55 0 160.550001 -5e-11 160.56 -5e-11 \
    160.560001 0 160.6 0 160.600001 -5e-11 160.61 -5e-11 \
    160.610001 0 160.65 0 160.650001 -5e-11 160.66 -5e-11 \
    160.660001 0 160.7 0 160.700001 -5e-11 160.71 -5e-11 \
    160.710001 0 160.75 0 160.750001 -5e-11 160.76 -5e-11 \
    160.760001 0 160.8 0 160.800001 -5e-11 160.81 -5e-11 \
    160.810001 0 160.85 0 160.850001 -5e-11 160.86 -5e-11 \
    160.860001 0 160.9 0 160.900001 -5e-11 160.91 -5e-11 \
    160.910001 0 160.95 0 160.950001 -5e-11 160.96 -5e-11 \
    160.960001 0 161 0 161.000001 -5e-11 161.01 -5e-11 \
    161.010001 0 161.05 0 161.050001 -5e-11 161.06 -5e-11 \
    161.060001 0 161.1 0 161.100001 -5e-11 161.11 -5e-11 \
    161.110001 0 161.15 0 161.150001 -5e-11 161.16 -5e-11 \
    161.160001 0 161.2 0 161.200001 -5e-11 161.21 -5e-11 \
    161.210001 0 161.25 0 161.250001 -5e-11 161.26 -5e-11 \
    161.260001 0 161.3 0 161.300001 -5e-11 161.31 -5e-11 \
    161.310001 0 161.35 0 161.350001 -5e-11 161.36 -5e-11 \
    161.360001 0 161.4 0 161.400001 -5e-11 161.41 -5e-11 \
    161.410001 0 161.45 0 161.450001 -5e-11 161.46 -5e-11 \
    161.460001 0 161.5 0 161.500001 -5e-11 161.51 -5e-11 \
    161.510001 0 161.55 0 161.550001 -5e-11 161.56 -5e-11 \
    161.560001 0 161.6 0 161.600001 -5e-11 161.61 -5e-11 \
    161.610001 0 161.65 0 161.650001 -5e-11 161.66 -5e-11 \
    161.660001 0 161.7 0 161.700001 -5e-11 161.71 -5e-11 \
    161.710001 0 161.75 0 161.750001 -5e-11 161.76 -5e-11 \
    161.760001 0 161.8 0 161.800001 -5e-11 161.81 -5e-11 \
    161.810001 0 161.85 0 161.850001 -5e-11 161.86 -5e-11 \
    161.860001 0 161.9 0 161.900001 -5e-11 161.91 -5e-11 \
    161.910001 0 161.95 0 161.950001 -5e-11 161.96 -5e-11 \
    161.960001 0 162 0 162.000001 -5e-11 162.01 -5e-11 \
    162.010001 0 162.05 0 162.050001 -5e-11 162.06 -5e-11 \
    162.060001 0 162.1 0 162.100001 -5e-11 162.11 -5e-11 \
    162.110001 0 162.15 0 162.150001 -5e-11 162.16 -5e-11 \
    162.160001 0 162.2 0 162.200001 -5e-11 162.21 -5e-11 \
    162.210001 0 162.25 0 162.250001 -5e-11 162.26 -5e-11 \
    162.260001 0 162.3 0 162.300001 -5e-11 162.31 -5e-11 \
    162.310001 0 162.35 0 162.350001 -5e-11 162.36 -5e-11 \
    162.360001 0 162.4 0 162.400001 -5e-11 162.41 -5e-11 \
    162.410001 0 162.45 0 162.450001 -5e-11 162.46 -5e-11 \
    162.460001 0 162.5 0 162.500001 -5e-11 162.51 -5e-11 \
    162.510001 0 162.55 0 162.550001 -5e-11 162.56 -5e-11 \
    162.560001 0 162.6 0 162.600001 -5e-11 162.61 -5e-11 \
    162.610001 0 162.65 0 162.650001 -5e-11 162.66 -5e-11 \
    162.660001 0 162.7 0 162.700001 -5e-11 162.71 -5e-11 \
    162.710001 0 162.75 0 162.750001 -5e-11 162.76 -5e-11 \
    162.760001 0 162.8 0 162.800001 -5e-11 162.81 -5e-11 \
    162.810001 0 162.85 0 162.850001 -5e-11 162.86 -5e-11 \
    162.860001 0 162.9 0 162.900001 -5e-11 162.91 -5e-11 \
    162.910001 0 162.95 0 162.950001 -5e-11 162.96 -5e-11 \
    162.960001 0 163 0 163.000001 -5e-11 163.01 -5e-11 \
    163.010001 0 163.05 0 163.050001 -5e-11 163.06 -5e-11 \
    163.060001 0 163.1 0 163.100001 -5e-11 163.11 -5e-11 \
    163.110001 0 163.15 0 163.150001 -5e-11 163.16 -5e-11 \
    163.160001 0 163.2 0 163.200001 -5e-11 163.21 -5e-11 \
    163.210001 0 163.25 0 163.250001 -5e-11 163.26 -5e-11 \
    163.260001 0 163.3 0 163.300001 -5e-11 163.31 -5e-11 \
    163.310001 0 163.35 0 163.350001 -5e-11 163.36 -5e-11 \
    163.360001 0 163.4 0 163.400001 -5e-11 163.41 -5e-11 \
    163.410001 0 163.45 0 163.450001 -5e-11 163.46 -5e-11 \
    163.460001 0 163.5 0 163.500001 -5e-11 163.51 -5e-11 \
    163.510001 0 163.55 0 163.550001 -5e-11 163.56 -5e-11 \
    163.560001 0 163.6 0 163.600001 -5e-11 163.61 -5e-11 \
    163.610001 0 163.65 0 163.650001 -5e-11 163.66 -5e-11 \
    163.660001 0 163.7 0 163.700001 -5e-11 163.71 -5e-11 \
    163.710001 0 163.75 0 163.750001 -5e-11 163.76 -5e-11 \
    163.760001 0 163.8 0 163.800001 -5e-11 163.81 -5e-11 \
    163.810001 0 163.85 0 163.850001 -5e-11 163.86 -5e-11 \
    163.860001 0 163.9 0 163.900001 -5e-11 163.91 -5e-11 \
    163.910001 0 163.95 0 163.950001 -5e-11 163.96 -5e-11 \
    163.960001 0 164 0 164.000001 -5e-11 164.01 -5e-11 \
    164.010001 0 164.05 0 164.050001 -5e-11 164.06 -5e-11 \
    164.060001 0 164.1 0 164.100001 -5e-11 164.11 -5e-11 \
    164.110001 0 164.15 0 164.150001 -5e-11 164.16 -5e-11 \
    164.160001 0 164.2 0 164.200001 -5e-11 164.21 -5e-11 \
    164.210001 0 164.25 0 164.250001 -5e-11 164.26 -5e-11 \
    164.260001 0 164.3 0 164.300001 -5e-11 164.31 -5e-11 \
    164.310001 0 164.35 0 164.350001 -5e-11 164.36 -5e-11 \
    164.360001 0 164.4 0 164.400001 -5e-11 164.41 -5e-11 \
    164.410001 0 164.45 0 164.450001 -5e-11 164.46 -5e-11 \
    164.460001 0 164.5 0 164.500001 -5e-11 164.51 -5e-11 \
    164.510001 0 164.55 0 164.550001 -5e-11 164.56 -5e-11 \
    164.560001 0 164.6 0 164.600001 -5e-11 164.61 -5e-11 \
    164.610001 0 164.65 0 164.650001 -5e-11 164.66 -5e-11 \
    164.660001 0 164.7 0 164.700001 -5e-11 164.71 -5e-11 \
    164.710001 0 164.75 0 164.750001 -5e-11 164.76 -5e-11 \
    164.760001 0 164.8 0 164.800001 -5e-11 164.81 -5e-11 \
    164.810001 0 164.85 0 164.850001 -5e-11 164.86 -5e-11 \
    164.860001 0 164.9 0 164.900001 -5e-11 164.91 -5e-11 \
    164.910001 0 164.95 0 164.950001 -5e-11 164.96 -5e-11 \
    164.960001 0 165 0 165.000001 -5e-11 165.01 -5e-11 \
    165.010001 0 165.05 0 165.050001 -5e-11 165.06 -5e-11 \
    165.060001 0 165.1 0 165.100001 -5e-11 165.11 -5e-11 \
    165.110001 0 165.15 0 165.150001 -5e-11 165.16 -5e-11 \
    165.160001 0 165.2 0 165.200001 -5e-11 165.21 -5e-11 \
    165.210001 0 165.25 0 165.250001 -5e-11 165.26 -5e-11 \
    165.260001 0 165.3 0 165.300001 -5e-11 165.31 -5e-11 \
    165.310001 0 165.35 0 165.350001 -5e-11 165.36 -5e-11 \
    165.360001 0 165.4 0 165.400001 -5e-11 165.41 -5e-11 \
    165.410001 0 165.45 0 165.450001 -5e-11 165.46 -5e-11 \
    165.460001 0 165.5 0 165.500001 -5e-11 165.51 -5e-11 \
    165.510001 0 165.55 0 165.550001 -5e-11 165.56 -5e-11 \
    165.560001 0 165.6 0 165.600001 -5e-11 165.61 -5e-11 \
    165.610001 0 165.65 0 165.650001 -5e-11 165.66 -5e-11 \
    165.660001 0 165.7 0 165.700001 -5e-11 165.71 -5e-11 \
    165.710001 0 165.75 0 165.750001 -5e-11 165.76 -5e-11 \
    165.760001 0 165.8 0 165.800001 -5e-11 165.81 -5e-11 \
    165.810001 0 165.85 0 165.850001 -5e-11 165.86 -5e-11 \
    165.860001 0 165.9 0 165.900001 -5e-11 165.91 -5e-11 \
    165.910001 0 165.95 0 165.950001 -5e-11 165.96 -5e-11 \
    165.960001 0 166 0 166.000001 -5e-11 166.01 -5e-11 \
    166.010001 0 166.05 0 166.050001 -5e-11 166.06 -5e-11 \
    166.060001 0 166.1 0 166.100001 -5e-11 166.11 -5e-11 \
    166.110001 0 166.15 0 166.150001 -5e-11 166.16 -5e-11 \
    166.160001 0 166.2 0 166.200001 -5e-11 166.21 -5e-11 \
    166.210001 0 166.25 0 166.250001 -5e-11 166.26 -5e-11 \
    166.260001 0 166.3 0 166.300001 -5e-11 166.31 -5e-11 \
    166.310001 0 166.35 0 166.350001 -5e-11 166.36 -5e-11 \
    166.360001 0 166.4 0 166.400001 -5e-11 166.41 -5e-11 \
    166.410001 0 166.45 0 166.450001 -5e-11 166.46 -5e-11 \
    166.460001 0 166.5 0 166.500001 -5e-11 166.51 -5e-11 \
    166.510001 0 166.55 0 166.550001 -5e-11 166.56 -5e-11 \
    166.560001 0 166.6 0 166.600001 -5e-11 166.61 -5e-11 \
    166.610001 0 166.65 0 166.650001 -5e-11 166.66 -5e-11 \
    166.660001 0 166.7 0 166.700001 -5e-11 166.71 -5e-11 \
    166.710001 0 166.75 0 166.750001 -5e-11 166.76 -5e-11 \
    166.760001 0 166.8 0 166.800001 -5e-11 166.81 -5e-11 \
    166.810001 0 166.85 0 166.850001 -5e-11 166.86 -5e-11 \
    166.860001 0 166.9 0 166.900001 -5e-11 166.91 -5e-11 \
    166.910001 0 166.95 0 166.950001 -5e-11 166.96 -5e-11 \
    166.960001 0 167 0 167.000001 -5e-11 167.01 -5e-11 \
    167.010001 0 167.05 0 167.050001 -5e-11 167.06 -5e-11 \
    167.060001 0 167.1 0 167.100001 -5e-11 167.11 -5e-11 \
    167.110001 0 167.15 0 167.150001 -5e-11 167.16 -5e-11 \
    167.160001 0 167.2 0 167.200001 -5e-11 167.21 -5e-11 \
    167.210001 0 167.25 0 167.250001 -5e-11 167.26 -5e-11 \
    167.260001 0 167.3 0 167.300001 -5e-11 167.31 -5e-11 \
    167.310001 0 167.35 0 167.350001 -5e-11 167.36 -5e-11 \
    167.360001 0 167.4 0 167.400001 -5e-11 167.41 -5e-11 \
    167.410001 0 167.45 0 167.450001 -5e-11 167.46 -5e-11 \
    167.460001 0 167.5 0 167.500001 -5e-11 167.51 -5e-11 \
    167.510001 0 167.55 0 167.550001 -5e-11 167.56 -5e-11 \
    167.560001 0 167.6 0 167.600001 -5e-11 167.61 -5e-11 \
    167.610001 0 167.65 0 167.650001 -5e-11 167.66 -5e-11 \
    167.660001 0 167.7 0 167.700001 -5e-11 167.71 -5e-11 \
    167.710001 0 167.75 0 167.750001 -5e-11 167.76 -5e-11 \
    167.760001 0 167.8 0 167.800001 -5e-11 167.81 -5e-11 \
    167.810001 0 167.85 0 167.850001 -5e-11 167.86 -5e-11 \
    167.860001 0 167.9 0 167.900001 -5e-11 167.91 -5e-11 \
    167.910001 0 167.95 0 167.950001 -5e-11 167.96 -5e-11 \
    167.960001 0 168 0 168.000001 -5e-11 168.01 -5e-11 \
    168.010001 0 168.05 0 168.050001 -5e-11 168.06 -5e-11 \
    168.060001 0 168.1 0 168.100001 -5e-11 168.11 -5e-11 \
    168.110001 0 168.15 0 168.150001 -5e-11 168.16 -5e-11 \
    168.160001 0 168.2 0 168.200001 -5e-11 168.21 -5e-11 \
    168.210001 0 168.25 0 168.250001 -5e-11 168.26 -5e-11 \
    168.260001 0 168.3 0 168.300001 -5e-11 168.31 -5e-11 \
    168.310001 0 168.35 0 168.350001 -5e-11 168.36 -5e-11 \
    168.360001 0 168.4 0 168.400001 -5e-11 168.41 -5e-11 \
    168.410001 0 168.45 0 168.450001 -5e-11 168.46 -5e-11 \
    168.460001 0 168.5 0 168.500001 -5e-11 168.51 -5e-11 \
    168.510001 0 168.55 0 168.550001 -5e-11 168.56 -5e-11 \
    168.560001 0 168.6 0 168.600001 -5e-11 168.61 -5e-11 \
    168.610001 0 168.65 0 168.650001 -5e-11 168.66 -5e-11 \
    168.660001 0 168.7 0 168.700001 -5e-11 168.71 -5e-11 \
    168.710001 0 168.75 0 168.750001 -5e-11 168.76 -5e-11 \
    168.760001 0 168.8 0 168.800001 -5e-11 168.81 -5e-11 \
    168.810001 0 168.85 0 168.850001 -5e-11 168.86 -5e-11 \
    168.860001 0 168.9 0 168.900001 -5e-11 168.91 -5e-11 \
    168.910001 0 168.95 0 168.950001 -5e-11 168.96 -5e-11 \
    168.960001 0 169 0 169.000001 -5e-11 169.01 -5e-11 \
    169.010001 0 169.05 0 169.050001 -5e-11 169.06 -5e-11 \
    169.060001 0 169.1 0 169.100001 -5e-11 169.11 -5e-11 \
    169.110001 0 169.15 0 169.150001 -5e-11 169.16 -5e-11 \
    169.160001 0 169.2 0 169.200001 -5e-11 169.21 -5e-11 \
    169.210001 0 169.25 0 169.250001 -5e-11 169.26 -5e-11 \
    169.260001 0 169.3 0 169.300001 -5e-11 169.31 -5e-11 \
    169.310001 0 169.35 0 169.350001 -5e-11 169.36 -5e-11 \
    169.360001 0 169.4 0 169.400001 -5e-11 169.41 -5e-11 \
    169.410001 0 169.45 0 169.450001 -5e-11 169.46 -5e-11 \
    169.460001 0 169.5 0 169.500001 -5e-11 169.51 -5e-11 \
    169.510001 0 169.55 0 169.550001 -5e-11 169.56 -5e-11 \
    169.560001 0 169.6 0 169.600001 -5e-11 169.61 -5e-11 \
    169.610001 0 169.65 0 169.650001 -5e-11 169.66 -5e-11 \
    169.660001 0 169.7 0 169.700001 -5e-11 169.71 -5e-11 \
    169.710001 0 169.75 0 169.750001 -5e-11 169.76 -5e-11 \
    169.760001 0 169.8 0 169.800001 -5e-11 169.81 -5e-11 \
    169.810001 0 169.85 0 169.850001 -5e-11 169.86 -5e-11 \
    169.860001 0 169.9 0 169.900001 -5e-11 169.91 -5e-11 \
    169.910001 0 169.95 0 169.950001 -5e-11 169.96 -5e-11 \
    169.960001 0 170 0 170.000001 -5e-11 170.01 -5e-11 \
    170.010001 0 170.05 0 170.050001 -5e-11 170.06 -5e-11 \
    170.060001 0 170.1 0 170.100001 -5e-11 170.11 -5e-11 \
    170.110001 0 170.15 0 170.150001 -5e-11 170.16 -5e-11 \
    170.160001 0 170.2 0 170.200001 -5e-11 170.21 -5e-11 \
    170.210001 0 170.25 0 170.250001 -5e-11 170.26 -5e-11 \
    170.260001 0 170.3 0 170.300001 -5e-11 170.31 -5e-11 \
    170.310001 0 170.35 0 170.350001 -5e-11 170.36 -5e-11 \
    170.360001 0 170.4 0 170.400001 -5e-11 170.41 -5e-11 \
    170.410001 0 170.45 0 170.450001 -5e-11 170.46 -5e-11 \
    170.460001 0 170.5 0 170.500001 -5e-11 170.51 -5e-11 \
    170.510001 0 170.55 0 170.550001 -5e-11 170.56 -5e-11 \
    170.560001 0 170.6 0 170.600001 -5e-11 170.61 -5e-11 \
    170.610001 0 170.65 0 170.650001 -5e-11 170.66 -5e-11 \
    170.660001 0 170.7 0 170.700001 -5e-11 170.71 -5e-11 \
    170.710001 0 170.75 0 170.750001 -5e-11 170.76 -5e-11 \
    170.760001 0 170.8 0 170.800001 -5e-11 170.81 -5e-11 \
    170.810001 0 170.85 0 170.850001 -5e-11 170.86 -5e-11 \
    170.860001 0 170.9 0 170.900001 -5e-11 170.91 -5e-11 \
    170.910001 0 170.95 0 170.950001 -5e-11 170.96 -5e-11 \
    170.960001 0 171 0 171.000001 -5e-11 171.01 -5e-11 \
    171.010001 0 171.05 0 171.050001 -5e-11 171.06 -5e-11 \
    171.060001 0 171.1 0 171.100001 -5e-11 171.11 -5e-11 \
    171.110001 0 171.15 0 171.150001 -5e-11 171.16 -5e-11 \
    171.160001 0 171.2 0 171.200001 -5e-11 171.21 -5e-11 \
    171.210001 0 171.25 0 171.250001 -5e-11 171.26 -5e-11 \
    171.260001 0 171.3 0 171.300001 -5e-11 171.31 -5e-11 \
    171.310001 0 171.35 0 171.350001 -5e-11 171.36 -5e-11 \
    171.360001 0 171.4 0 171.400001 -5e-11 171.41 -5e-11 \
    171.410001 0 171.45 0 171.450001 -5e-11 171.46 -5e-11 \
    171.460001 0 171.5 0 171.500001 -5e-11 171.51 -5e-11 \
    171.510001 0 171.55 0 171.550001 -5e-11 171.56 -5e-11 \
    171.560001 0 171.6 0 171.600001 -5e-11 171.61 -5e-11 \
    171.610001 0 171.65 0 171.650001 -5e-11 171.66 -5e-11 \
    171.660001 0 171.7 0 171.700001 -5e-11 171.71 -5e-11 \
    171.710001 0 171.75 0 171.750001 -5e-11 171.76 -5e-11 \
    171.760001 0 171.8 0 171.800001 -5e-11 171.81 -5e-11 \
    171.810001 0 171.85 0 171.850001 -5e-11 171.86 -5e-11 \
    171.860001 0 171.9 0 171.900001 -5e-11 171.91 -5e-11 \
    171.910001 0 171.95 0 171.950001 -5e-11 171.96 -5e-11 \
    171.960001 0 172 0 172.000001 -5e-11 172.01 -5e-11 \
    172.010001 0 172.05 0 172.050001 -5e-11 172.06 -5e-11 \
    172.060001 0 172.1 0 172.100001 -5e-11 172.11 -5e-11 \
    172.110001 0 172.15 0 172.150001 -5e-11 172.16 -5e-11 \
    172.160001 0 172.2 0 172.200001 -5e-11 172.21 -5e-11 \
    172.210001 0 172.25 0 172.250001 -5e-11 172.26 -5e-11 \
    172.260001 0 172.3 0 172.300001 -5e-11 172.31 -5e-11 \
    172.310001 0 172.35 0 172.350001 -5e-11 172.36 -5e-11 \
    172.360001 0 172.4 0 172.400001 -5e-11 172.41 -5e-11 \
    172.410001 0 172.45 0 172.450001 -5e-11 172.46 -5e-11 \
    172.460001 0 172.5 0 172.500001 -5e-11 172.51 -5e-11 \
    172.510001 0 172.55 0 172.550001 -5e-11 172.56 -5e-11 \
    172.560001 0 172.6 0 172.600001 -5e-11 172.61 -5e-11 \
    172.610001 0 172.65 0 172.650001 -5e-11 172.66 -5e-11 \
    172.660001 0 172.7 0 172.700001 -5e-11 172.71 -5e-11 \
    172.710001 0 172.75 0 172.750001 -5e-11 172.76 -5e-11 \
    172.760001 0 172.8 0 172.800001 -5e-11 172.81 -5e-11 \
    172.810001 0 172.85 0 172.850001 -5e-11 172.86 -5e-11 \
    172.860001 0 172.9 0 172.900001 -5e-11 172.91 -5e-11 \
    172.910001 0 172.95 0 172.950001 -5e-11 172.96 -5e-11 \
    172.960001 0 173 0 173.000001 -5e-11 173.01 -5e-11 \
    173.010001 0 173.05 0 173.050001 -5e-11 173.06 -5e-11 \
    173.060001 0 173.1 0 173.100001 -5e-11 173.11 -5e-11 \
    173.110001 0 173.15 0 173.150001 -5e-11 173.16 -5e-11 \
    173.160001 0 173.2 0 173.200001 -5e-11 173.21 -5e-11 \
    173.210001 0 173.25 0 173.250001 -5e-11 173.26 -5e-11 \
    173.260001 0 173.3 0 173.300001 -5e-11 173.31 -5e-11 \
    173.310001 0 173.35 0 173.350001 -5e-11 173.36 -5e-11 \
    173.360001 0 173.4 0 173.400001 -5e-11 173.41 -5e-11 \
    173.410001 0 173.45 0 173.450001 -5e-11 173.46 -5e-11 \
    173.460001 0 173.5 0 173.500001 -5e-11 173.51 -5e-11 \
    173.510001 0 173.55 0 173.550001 -5e-11 173.56 -5e-11 \
    173.560001 0 173.6 0 173.600001 -5e-11 173.61 -5e-11 \
    173.610001 0 173.65 0 173.650001 -5e-11 173.66 -5e-11 \
    173.660001 0 173.7 0 173.700001 -5e-11 173.71 -5e-11 \
    173.710001 0 173.75 0 173.750001 -5e-11 173.76 -5e-11 \
    173.760001 0 173.8 0 173.800001 -5e-11 173.81 -5e-11 \
    173.810001 0 173.85 0 173.850001 -5e-11 173.86 -5e-11 \
    173.860001 0 173.9 0 173.900001 -5e-11 173.91 -5e-11 \
    173.910001 0 173.95 0 173.950001 -5e-11 173.96 -5e-11 \
    173.960001 0 174 0 174.000001 -5e-11 174.01 -5e-11 \
    174.010001 0 174.05 0 174.050001 -5e-11 174.06 -5e-11 \
    174.060001 0 174.1 0 174.100001 -5e-11 174.11 -5e-11 \
    174.110001 0 174.15 0 174.150001 -5e-11 174.16 -5e-11 \
    174.160001 0 174.2 0 174.200001 -5e-11 174.21 -5e-11 \
    174.210001 0 174.25 0 174.250001 -5e-11 174.26 -5e-11 \
    174.260001 0 174.3 0 174.300001 -5e-11 174.31 -5e-11 \
    174.310001 0 174.35 0 174.350001 -5e-11 174.36 -5e-11 \
    174.360001 0 174.4 0 174.400001 -5e-11 174.41 -5e-11 \
    174.410001 0 174.45 0 174.450001 -5e-11 174.46 -5e-11 \
    174.460001 0 174.5 0 174.500001 -5e-11 174.51 -5e-11 \
    174.510001 0 174.55 0 174.550001 -5e-11 174.56 -5e-11 \
    174.560001 0 174.6 0 174.600001 -5e-11 174.61 -5e-11 \
    174.610001 0 174.65 0 174.650001 -5e-11 174.66 -5e-11 \
    174.660001 0 174.7 0 174.700001 -5e-11 174.71 -5e-11 \
    174.710001 0 174.75 0 174.750001 -5e-11 174.76 -5e-11 \
    174.760001 0 174.8 0 174.800001 -5e-11 174.81 -5e-11 \
    174.810001 0 174.85 0 174.850001 -5e-11 174.86 -5e-11 \
    174.860001 0 174.9 0 174.900001 -5e-11 174.91 -5e-11 \
    174.910001 0 174.95 0 174.950001 -5e-11 174.96 -5e-11 \
    174.960001 0 175 0 175.000001 -5e-11 175.01 -5e-11 \
    175.010001 0 175.05 0 175.050001 -5e-11 175.06 -5e-11 \
    175.060001 0 175.1 0 175.100001 -5e-11 175.11 -5e-11 \
    175.110001 0 175.15 0 175.150001 -5e-11 175.16 -5e-11 \
    175.160001 0 175.2 0 175.200001 -5e-11 175.21 -5e-11 \
    175.210001 0 175.25 0 175.250001 -5e-11 175.26 -5e-11 \
    175.260001 0 175.3 0 175.300001 -5e-11 175.31 -5e-11 \
    175.310001 0 175.35 0 175.350001 -5e-11 175.36 -5e-11 \
    175.360001 0 175.4 0 175.400001 -5e-11 175.41 -5e-11 \
    175.410001 0 175.45 0 175.450001 -5e-11 175.46 -5e-11 \
    175.460001 0 175.5 0 175.500001 -5e-11 175.51 -5e-11 \
    175.510001 0 175.55 0 175.550001 -5e-11 175.56 -5e-11 \
    175.560001 0 175.6 0 175.600001 -5e-11 175.61 -5e-11 \
    175.610001 0 175.65 0 175.650001 -5e-11 175.66 -5e-11 \
    175.660001 0 175.7 0 175.700001 -5e-11 175.71 -5e-11 \
    175.710001 0 175.75 0 175.750001 -5e-11 175.76 -5e-11 \
    175.760001 0 175.8 0 175.800001 -5e-11 175.81 -5e-11 \
    175.810001 0 175.85 0 175.850001 -5e-11 175.86 -5e-11 \
    175.860001 0 175.9 0 175.900001 -5e-11 175.91 -5e-11 \
    175.910001 0 175.95 0 175.950001 -5e-11 175.96 -5e-11 \
    175.960001 0 176 0 176.000001 -5e-11 176.01 -5e-11 \
    176.010001 0 176.05 0 176.050001 -5e-11 176.06 -5e-11 \
    176.060001 0 176.1 0 176.100001 -5e-11 176.11 -5e-11 \
    176.110001 0 176.15 0 176.150001 -5e-11 176.16 -5e-11 \
    176.160001 0 176.2 0 176.200001 -5e-11 176.21 -5e-11 \
    176.210001 0 176.25 0 176.250001 -5e-11 176.26 -5e-11 \
    176.260001 0 176.3 0 176.300001 -5e-11 176.31 -5e-11 \
    176.310001 0 176.35 0 176.350001 -5e-11 176.36 -5e-11 \
    176.360001 0 176.4 0 176.400001 -5e-11 176.41 -5e-11 \
    176.410001 0 176.45 0 176.450001 -5e-11 176.46 -5e-11 \
    176.460001 0 176.5 0 176.500001 -5e-11 176.51 -5e-11 \
    176.510001 0 176.55 0 176.550001 -5e-11 176.56 -5e-11 \
    176.560001 0 176.6 0 176.600001 -5e-11 176.61 -5e-11 \
    176.610001 0 176.65 0 176.650001 -5e-11 176.66 -5e-11 \
    176.660001 0 176.7 0 176.700001 -5e-11 176.71 -5e-11 \
    176.710001 0 176.75 0 176.750001 -5e-11 176.76 -5e-11 \
    176.760001 0 176.8 0 176.800001 -5e-11 176.81 -5e-11 \
    176.810001 0 176.85 0 176.850001 -5e-11 176.86 -5e-11 \
    176.860001 0 176.9 0 176.900001 -5e-11 176.91 -5e-11 \
    176.910001 0 176.95 0 176.950001 -5e-11 176.96 -5e-11 \
    176.960001 0 177 0 177.000001 -5e-11 177.01 -5e-11 \
    177.010001 0 177.05 0 177.050001 -5e-11 177.06 -5e-11 \
    177.060001 0 177.1 0 177.100001 -5e-11 177.11 -5e-11 \
    177.110001 0 177.15 0 177.150001 -5e-11 177.16 -5e-11 \
    177.160001 0 177.2 0 177.200001 -5e-11 177.21 -5e-11 \
    177.210001 0 177.25 0 177.250001 -5e-11 177.26 -5e-11 \
    177.260001 0 177.3 0 177.300001 -5e-11 177.31 -5e-11 \
    177.310001 0 177.35 0 177.350001 -5e-11 177.36 -5e-11 \
    177.360001 0 177.4 0 177.400001 -5e-11 177.41 -5e-11 \
    177.410001 0 177.45 0 177.450001 -5e-11 177.46 -5e-11 \
    177.460001 0 177.5 0 177.500001 -5e-11 177.51 -5e-11 \
    177.510001 0 177.55 0 177.550001 -5e-11 177.56 -5e-11 \
    177.560001 0 177.6 0 177.600001 -5e-11 177.61 -5e-11 \
    177.610001 0 177.65 0 177.650001 -5e-11 177.66 -5e-11 \
    177.660001 0 177.7 0 177.700001 -5e-11 177.71 -5e-11 \
    177.710001 0 177.75 0 177.750001 -5e-11 177.76 -5e-11 \
    177.760001 0 177.8 0 177.800001 -5e-11 177.81 -5e-11 \
    177.810001 0 177.85 0 177.850001 -5e-11 177.86 -5e-11 \
    177.860001 0 177.9 0 177.900001 -5e-11 177.91 -5e-11 \
    177.910001 0 177.95 0 177.950001 -5e-11 177.96 -5e-11 \
    177.960001 0 178 0 178.000001 -5e-11 178.01 -5e-11 \
    178.010001 0 178.05 0 178.050001 -5e-11 178.06 -5e-11 \
    178.060001 0 178.1 0 178.100001 -5e-11 178.11 -5e-11 \
    178.110001 0 178.15 0 178.150001 -5e-11 178.16 -5e-11 \
    178.160001 0 178.2 0 178.200001 -5e-11 178.21 -5e-11 \
    178.210001 0 178.25 0 178.250001 -5e-11 178.26 -5e-11 \
    178.260001 0 178.3 0 178.300001 -5e-11 178.31 -5e-11 \
    178.310001 0 178.35 0 178.350001 -5e-11 178.36 -5e-11 \
    178.360001 0 178.4 0 178.400001 -5e-11 178.41 -5e-11 \
    178.410001 0 178.45 0 178.450001 -5e-11 178.46 -5e-11 \
    178.460001 0 178.5 0 178.500001 -5e-11 178.51 -5e-11 \
    178.510001 0 178.55 0 178.550001 -5e-11 178.56 -5e-11 \
    178.560001 0 178.6 0 178.600001 -5e-11 178.61 -5e-11 \
    178.610001 0 178.65 0 178.650001 -5e-11 178.66 -5e-11 \
    178.660001 0 178.7 0 178.700001 -5e-11 178.71 -5e-11 \
    178.710001 0 178.75 0 178.750001 -5e-11 178.76 -5e-11 \
    178.760001 0 178.8 0 178.800001 -5e-11 178.81 -5e-11 \
    178.810001 0 178.85 0 178.850001 -5e-11 178.86 -5e-11 \
    178.860001 0 178.9 0 178.900001 -5e-11 178.91 -5e-11 \
    178.910001 0 178.95 0 178.950001 -5e-11 178.96 -5e-11 \
    178.960001 0 179 0 179.000001 -5e-11 179.01 -5e-11 \
    179.010001 0 179.05 0 179.050001 -5e-11 179.06 -5e-11 \
    179.060001 0 179.1 0 179.100001 -5e-11 179.11 -5e-11 \
    179.110001 0 179.15 0 179.150001 -5e-11 179.16 -5e-11 \
    179.160001 0 179.2 0 179.200001 -5e-11 179.21 -5e-11 \
    179.210001 0 179.25 0 179.250001 -5e-11 179.26 -5e-11 \
    179.260001 0 179.3 0 179.300001 -5e-11 179.31 -5e-11 \
    179.310001 0 179.35 0 179.350001 -5e-11 179.36 -5e-11 \
    179.360001 0 179.4 0 179.400001 -5e-11 179.41 -5e-11 \
    179.410001 0 179.45 0 179.450001 -5e-11 179.46 -5e-11 \
    179.460001 0 179.5 0 179.500001 -5e-11 179.51 -5e-11 \
    179.510001 0 179.55 0 179.550001 -5e-11 179.56 -5e-11 \
    179.560001 0 179.6 0 179.600001 -5e-11 179.61 -5e-11 \
    179.610001 0 179.65 0 179.650001 -5e-11 179.66 -5e-11 \
    179.660001 0 179.7 0 179.700001 -5e-11 179.71 -5e-11 \
    179.710001 0 179.75 0 179.750001 -5e-11 179.76 -5e-11 \
    179.760001 0 179.8 0 179.800001 -5e-11 179.81 -5e-11 \
    179.810001 0 179.85 0 179.850001 -5e-11 179.86 -5e-11 \
    179.860001 0 179.9 0 179.900001 -5e-11 179.91 -5e-11 \
    179.910001 0 179.95 0 179.950001 -5e-11 179.96 -5e-11 \
    179.960001 0 180 0 180.000001 -5e-11 180.01 -5e-11 \
    180.010001 0 180.05 0 180.050001 -5e-11 180.06 -5e-11 \
    180.060001 0 180.1 0 180.100001 -5e-11 180.11 -5e-11 \
    180.110001 0 180.15 0 180.150001 -5e-11 180.16 -5e-11 \
    180.160001 0 180.2 0 180.200001 -5e-11 180.21 -5e-11 \
    180.210001 0 180.25 0 180.250001 -5e-11 180.26 -5e-11 \
    180.260001 0 180.3 0 180.300001 -5e-11 180.31 -5e-11 \
    180.310001 0 180.35 0 180.350001 -5e-11 180.36 -5e-11 \
    180.360001 0 180.4 0 180.400001 -5e-11 180.41 -5e-11 \
    180.410001 0 180.45 0 180.450001 -5e-11 180.46 -5e-11 \
    180.460001 0 180.5 0 180.500001 -5e-11 180.51 -5e-11 \
    180.510001 0 180.55 0 180.550001 -5e-11 180.56 -5e-11 \
    180.560001 0 180.6 0 180.600001 -5e-11 180.61 -5e-11 \
    180.610001 0 180.65 0 180.650001 -5e-11 180.66 -5e-11 \
    180.660001 0 180.7 0 180.700001 -5e-11 180.71 -5e-11 \
    180.710001 0 180.75 0 180.750001 -5e-11 180.76 -5e-11 \
    180.760001 0 180.8 0 180.800001 -5e-11 180.81 -5e-11 \
    180.810001 0 180.85 0 180.850001 -5e-11 180.86 -5e-11 \
    180.860001 0 180.9 0 180.900001 -5e-11 180.91 -5e-11 \
    180.910001 0 180.95 0 180.950001 -5e-11 180.96 -5e-11 \
    180.960001 0 181 0 181.000001 -5e-11 181.01 -5e-11 \
    181.010001 0 181.05 0 181.050001 -5e-11 181.06 -5e-11 \
    181.060001 0 181.1 0 181.100001 -5e-11 181.11 -5e-11 \
    181.110001 0 181.15 0 181.150001 -5e-11 181.16 -5e-11 \
    181.160001 0 181.2 0 181.200001 -5e-11 181.21 -5e-11 \
    181.210001 0 181.25 0 181.250001 -5e-11 181.26 -5e-11 \
    181.260001 0 181.3 0 181.300001 -5e-11 181.31 -5e-11 \
    181.310001 0 181.35 0 181.350001 -5e-11 181.36 -5e-11 \
    181.360001 0 181.4 0 181.400001 -5e-11 181.41 -5e-11 \
    181.410001 0 181.45 0 181.450001 -5e-11 181.46 -5e-11 \
    181.460001 0 181.5 0 181.500001 -5e-11 181.51 -5e-11 \
    181.510001 0 181.55 0 181.550001 -5e-11 181.56 -5e-11 \
    181.560001 0 181.6 0 181.600001 -5e-11 181.61 -5e-11 \
    181.610001 0 181.65 0 181.650001 -5e-11 181.66 -5e-11 \
    181.660001 0 181.7 0 181.700001 -5e-11 181.71 -5e-11 \
    181.710001 0 181.75 0 181.750001 -5e-11 181.76 -5e-11 \
    181.760001 0 181.8 0 181.800001 -5e-11 181.81 -5e-11 \
    181.810001 0 181.85 0 181.850001 -5e-11 181.86 -5e-11 \
    181.860001 0 181.9 0 181.900001 -5e-11 181.91 -5e-11 \
    181.910001 0 181.95 0 181.950001 -5e-11 181.96 -5e-11 \
    181.960001 0 182 0 182.000001 -5e-11 182.01 -5e-11 \
    182.010001 0 182.05 0 182.050001 -5e-11 182.06 -5e-11 \
    182.060001 0 182.1 0 182.100001 -5e-11 182.11 -5e-11 \
    182.110001 0 182.15 0 182.150001 -5e-11 182.16 -5e-11 \
    182.160001 0 182.2 0 182.200001 -5e-11 182.21 -5e-11 \
    182.210001 0 182.25 0 182.250001 -5e-11 182.26 -5e-11 \
    182.260001 0 182.3 0 182.300001 -5e-11 182.31 -5e-11 \
    182.310001 0 182.35 0 182.350001 -5e-11 182.36 -5e-11 \
    182.360001 0 182.4 0 182.400001 -5e-11 182.41 -5e-11 \
    182.410001 0 182.45 0 182.450001 -5e-11 182.46 -5e-11 \
    182.460001 0 182.5 0 182.500001 -5e-11 182.51 -5e-11 \
    182.510001 0 182.55 0 182.550001 -5e-11 182.56 -5e-11 \
    182.560001 0 182.6 0 182.600001 -5e-11 182.61 -5e-11 \
    182.610001 0 182.65 0 182.650001 -5e-11 182.66 -5e-11 \
    182.660001 0 182.7 0 182.700001 -5e-11 182.71 -5e-11 \
    182.710001 0 182.75 0 182.750001 -5e-11 182.76 -5e-11 \
    182.760001 0 182.8 0 182.800001 -5e-11 182.81 -5e-11 \
    182.810001 0 182.85 0 182.850001 -5e-11 182.86 -5e-11 \
    182.860001 0 182.9 0 182.900001 -5e-11 182.91 -5e-11 \
    182.910001 0 182.95 0 182.950001 -5e-11 182.96 -5e-11 \
    182.960001 0 183 0 183.000001 -5e-11 183.01 -5e-11 \
    183.010001 0 183.05 0 183.050001 -5e-11 183.06 -5e-11 \
    183.060001 0 183.1 0 183.100001 -5e-11 183.11 -5e-11 \
    183.110001 0 183.15 0 183.150001 -5e-11 183.16 -5e-11 \
    183.160001 0 183.2 0 183.200001 -5e-11 183.21 -5e-11 \
    183.210001 0 183.25 0 183.250001 -5e-11 183.26 -5e-11 \
    183.260001 0 183.3 0 183.300001 -5e-11 183.31 -5e-11 \
    183.310001 0 183.35 0 183.350001 -5e-11 183.36 -5e-11 \
    183.360001 0 183.4 0 183.400001 -5e-11 183.41 -5e-11 \
    183.410001 0 183.45 0 183.450001 -5e-11 183.46 -5e-11 \
    183.460001 0 183.5 0 183.500001 -5e-11 183.51 -5e-11 \
    183.510001 0 183.55 0 183.550001 -5e-11 183.56 -5e-11 \
    183.560001 0 183.6 0 183.600001 -5e-11 183.61 -5e-11 \
    183.610001 0 183.65 0 183.650001 -5e-11 183.66 -5e-11 \
    183.660001 0 183.7 0 183.700001 -5e-11 183.71 -5e-11 \
    183.710001 0 183.75 0 183.750001 -5e-11 183.76 -5e-11 \
    183.760001 0 183.8 0 183.800001 -5e-11 183.81 -5e-11 \
    183.810001 0 183.85 0 183.850001 -5e-11 183.86 -5e-11 \
    183.860001 0 183.9 0 183.900001 -5e-11 183.91 -5e-11 \
    183.910001 0 183.95 0 183.950001 -5e-11 183.96 -5e-11 \
    183.960001 0 184 0 184.000001 -5e-11 184.01 -5e-11 \
    184.010001 0 184.05 0 184.050001 -5e-11 184.06 -5e-11 \
    184.060001 0 184.1 0 184.100001 -5e-11 184.11 -5e-11 \
    184.110001 0 184.15 0 184.150001 -5e-11 184.16 -5e-11 \
    184.160001 0 184.2 0 184.200001 -5e-11 184.21 -5e-11 \
    184.210001 0 184.25 0 184.250001 -5e-11 184.26 -5e-11 \
    184.260001 0 184.3 0 184.300001 -5e-11 184.31 -5e-11 \
    184.310001 0 184.35 0 184.350001 -5e-11 184.36 -5e-11 \
    184.360001 0 184.4 0 184.400001 -5e-11 184.41 -5e-11 \
    184.410001 0 184.45 0 184.450001 -5e-11 184.46 -5e-11 \
    184.460001 0 184.5 0 184.500001 -5e-11 184.51 -5e-11 \
    184.510001 0 184.55 0 184.550001 -5e-11 184.56 -5e-11 \
    184.560001 0 184.6 0 184.600001 -5e-11 184.61 -5e-11 \
    184.610001 0 184.65 0 184.650001 -5e-11 184.66 -5e-11 \
    184.660001 0 184.7 0 184.700001 -5e-11 184.71 -5e-11 \
    184.710001 0 184.75 0 184.750001 -5e-11 184.76 -5e-11 \
    184.760001 0 184.8 0 184.800001 -5e-11 184.81 -5e-11 \
    184.810001 0 184.85 0 184.850001 -5e-11 184.86 -5e-11 \
    184.860001 0 184.9 0 184.900001 -5e-11 184.91 -5e-11 \
    184.910001 0 184.95 0 184.950001 -5e-11 184.96 -5e-11 \
    184.960001 0 185 0 185.000001 -5e-11 185.01 -5e-11 \
    185.010001 0 185.05 0 185.050001 -5e-11 185.06 -5e-11 \
    185.060001 0 185.1 0 185.100001 -5e-11 185.11 -5e-11 \
    185.110001 0 185.15 0 185.150001 -5e-11 185.16 -5e-11 \
    185.160001 0 185.2 0 185.200001 -5e-11 185.21 -5e-11 \
    185.210001 0 185.25 0 185.250001 -5e-11 185.26 -5e-11 \
    185.260001 0 185.3 0 185.300001 -5e-11 185.31 -5e-11 \
    185.310001 0 185.35 0 185.350001 -5e-11 185.36 -5e-11 \
    185.360001 0 185.4 0 185.400001 -5e-11 185.41 -5e-11 \
    185.410001 0 185.45 0 185.450001 -5e-11 185.46 -5e-11 \
    185.460001 0 185.5 0 185.500001 -5e-11 185.51 -5e-11 \
    185.510001 0 185.55 0 185.550001 -5e-11 185.56 -5e-11 \
    185.560001 0 185.6 0 185.600001 -5e-11 185.61 -5e-11 \
    185.610001 0 185.65 0 185.650001 -5e-11 185.66 -5e-11 \
    185.660001 0 185.7 0 185.700001 -5e-11 185.71 -5e-11 \
    185.710001 0 185.75 0 185.750001 -5e-11 185.76 -5e-11 \
    185.760001 0 185.8 0 185.800001 -5e-11 185.81 -5e-11 \
    185.810001 0 185.85 0 185.850001 -5e-11 185.86 -5e-11 \
    185.860001 0 185.9 0 185.900001 -5e-11 185.91 -5e-11 \
    185.910001 0 185.95 0 185.950001 -5e-11 185.96 -5e-11 \
    185.960001 0 186 0 186.000001 -5e-11 186.01 -5e-11 \
    186.010001 0 186.05 0 186.050001 -5e-11 186.06 -5e-11 \
    186.060001 0 186.1 0 186.100001 -5e-11 186.11 -5e-11 \
    186.110001 0 186.15 0 186.150001 -5e-11 186.16 -5e-11 \
    186.160001 0 186.2 0 186.200001 -5e-11 186.21 -5e-11 \
    186.210001 0 186.25 0 186.250001 -5e-11 186.26 -5e-11 \
    186.260001 0 186.3 0 186.300001 -5e-11 186.31 -5e-11 \
    186.310001 0 186.35 0 186.350001 -5e-11 186.36 -5e-11 \
    186.360001 0 186.4 0 186.400001 -5e-11 186.41 -5e-11 \
    186.410001 0 186.45 0 186.450001 -5e-11 186.46 -5e-11 \
    186.460001 0 186.5 0 186.500001 -5e-11 186.51 -5e-11 \
    186.510001 0 186.55 0 186.550001 -5e-11 186.56 -5e-11 \
    186.560001 0 186.6 0 186.600001 -5e-11 186.61 -5e-11 \
    186.610001 0 186.65 0 186.650001 -5e-11 186.66 -5e-11 \
    186.660001 0 186.7 0 186.700001 -5e-11 186.71 -5e-11 \
    186.710001 0 186.75 0 186.750001 -5e-11 186.76 -5e-11 \
    186.760001 0 186.8 0 186.800001 -5e-11 186.81 -5e-11 \
    186.810001 0 186.85 0 186.850001 -5e-11 186.86 -5e-11 \
    186.860001 0 186.9 0 186.900001 -5e-11 186.91 -5e-11 \
    186.910001 0 186.95 0 186.950001 -5e-11 186.96 -5e-11 \
    186.960001 0 187 0 187.000001 -5e-11 187.01 -5e-11 \
    187.010001 0 187.05 0 187.050001 -5e-11 187.06 -5e-11 \
    187.060001 0 187.1 0 187.100001 -5e-11 187.11 -5e-11 \
    187.110001 0 187.15 0 187.150001 -5e-11 187.16 -5e-11 \
    187.160001 0 187.2 0 187.200001 -5e-11 187.21 -5e-11 \
    187.210001 0 187.25 0 187.250001 -5e-11 187.26 -5e-11 \
    187.260001 0 187.3 0 187.300001 -5e-11 187.31 -5e-11 \
    187.310001 0 187.35 0 187.350001 -5e-11 187.36 -5e-11 \
    187.360001 0 187.4 0 187.400001 -5e-11 187.41 -5e-11 \
    187.410001 0 187.45 0 187.450001 -5e-11 187.46 -5e-11 \
    187.460001 0 187.5 0 187.500001 -5e-11 187.51 -5e-11 \
    187.510001 0 187.55 0 187.550001 -5e-11 187.56 -5e-11 \
    187.560001 0 187.6 0 187.600001 -5e-11 187.61 -5e-11 \
    187.610001 0 187.65 0 187.650001 -5e-11 187.66 -5e-11 \
    187.660001 0 187.7 0 187.700001 -5e-11 187.71 -5e-11 \
    187.710001 0 187.75 0 187.750001 -5e-11 187.76 -5e-11 \
    187.760001 0 187.8 0 187.800001 -5e-11 187.81 -5e-11 \
    187.810001 0 187.85 0 187.850001 -5e-11 187.86 -5e-11 \
    187.860001 0 187.9 0 187.900001 -5e-11 187.91 -5e-11 \
    187.910001 0 187.95 0 187.950001 -5e-11 187.96 -5e-11 \
    187.960001 0 188 0 188.000001 -5e-11 188.01 -5e-11 \
    188.010001 0 188.05 0 188.050001 -5e-11 188.06 -5e-11 \
    188.060001 0 188.1 0 188.100001 -5e-11 188.11 -5e-11 \
    188.110001 0 188.15 0 188.150001 -5e-11 188.16 -5e-11 \
    188.160001 0 188.2 0 188.200001 -5e-11 188.21 -5e-11 \
    188.210001 0 188.25 0 188.250001 -5e-11 188.26 -5e-11 \
    188.260001 0 188.3 0 188.300001 -5e-11 188.31 -5e-11 \
    188.310001 0 188.35 0 188.350001 -5e-11 188.36 -5e-11 \
    188.360001 0 188.4 0 188.400001 -5e-11 188.41 -5e-11 \
    188.410001 0 188.45 0 188.450001 -5e-11 188.46 -5e-11 \
    188.460001 0 188.5 0 188.500001 -5e-11 188.51 -5e-11 \
    188.510001 0 188.55 0 188.550001 -5e-11 188.56 -5e-11 \
    188.560001 0 188.6 0 188.600001 -5e-11 188.61 -5e-11 \
    188.610001 0 188.65 0 188.650001 -5e-11 188.66 -5e-11 \
    188.660001 0 188.7 0 188.700001 -5e-11 188.71 -5e-11 \
    188.710001 0 188.75 0 188.750001 -5e-11 188.76 -5e-11 \
    188.760001 0 188.8 0 188.800001 -5e-11 188.81 -5e-11 \
    188.810001 0 188.85 0 188.850001 -5e-11 188.86 -5e-11 \
    188.860001 0 188.9 0 188.900001 -5e-11 188.91 -5e-11 \
    188.910001 0 188.95 0 188.950001 -5e-11 188.96 -5e-11 \
    188.960001 0 189 0 189.000001 -5e-11 189.01 -5e-11 \
    189.010001 0 189.05 0 189.050001 -5e-11 189.06 -5e-11 \
    189.060001 0 189.1 0 189.100001 -5e-11 189.11 -5e-11 \
    189.110001 0 189.15 0 189.150001 -5e-11 189.16 -5e-11 \
    189.160001 0 189.2 0 189.200001 -5e-11 189.21 -5e-11 \
    189.210001 0 189.25 0 189.250001 -5e-11 189.26 -5e-11 \
    189.260001 0 189.3 0 189.300001 -5e-11 189.31 -5e-11 \
    189.310001 0 189.35 0 189.350001 -5e-11 189.36 -5e-11 \
    189.360001 0 189.4 0 189.400001 -5e-11 189.41 -5e-11 \
    189.410001 0 189.45 0 189.450001 -5e-11 189.46 -5e-11 \
    189.460001 0 189.5 0 189.500001 -5e-11 189.51 -5e-11 \
    189.510001 0 189.55 0 189.550001 -5e-11 189.56 -5e-11 \
    189.560001 0 189.6 0 189.600001 -5e-11 189.61 -5e-11 \
    189.610001 0 189.65 0 189.650001 -5e-11 189.66 -5e-11 \
    189.660001 0 189.7 0 189.700001 -5e-11 189.71 -5e-11 \
    189.710001 0 189.75 0 189.750001 -5e-11 189.76 -5e-11 \
    189.760001 0 189.8 0 189.800001 -5e-11 189.81 -5e-11 \
    189.810001 0 189.85 0 189.850001 -5e-11 189.86 -5e-11 \
    189.860001 0 189.9 0 189.900001 -5e-11 189.91 -5e-11 \
    189.910001 0 189.95 0 189.950001 -5e-11 189.96 -5e-11 \
    189.960001 0 190 0 190.000001 -5e-11 190.01 -5e-11 \
    190.010001 0 190.05 0 190.050001 -5e-11 190.06 -5e-11 \
    190.060001 0 190.6 0 ]
Rshunt (n_igsc 0) resistor r=1G   // DC path for the IGsc sense node

// initial state (n_nv = 1/Rinit (also forced by the .va's analysis("ic") branch))
ic X1.n_nv=0.000227272727273 X1.n_v1=0 X1.n_v2=0 X1.n_v3=0

tran tran stop=190.6 maxstep=0.005 errpreset=conservative ic=node

save n_rmem X1.n_nv X1.n_v1 X1.n_v2 X1.n_v3 X1.n_stdp vread:p X1:IGsc
