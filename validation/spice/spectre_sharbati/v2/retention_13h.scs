// retention_13h.scs - GENERATED by validation/paper/make_decks_paper.py; do not edit.
// Paper overlay deck (Sharbati et al., Adv. Mater. 30, 1802353 (2018)): ecfet_v2 under 'retention_13h'
//   one +50 pA / 10 ms pulse, settle to 300 s (dt 10 ms), then 13 h hold (dt 60 s)
// stimulus set sharbati-1 (d133e46493727894), t_stop 47100 s
//
// Run (writes retention_13h.raw/tran.tran in PSF-ascii):
//   spectre +escchars -format psfascii -raw retention_13h.raw +log retention_13h.log retention_13h.scs
// then import with validation/paper/scrub_paper.py (see validation/README.md).

simulator lang=spectre
global 0

ahdl_include "../../../../verilog/ecfet_v2.va"

simOpts options reltol=1e-6 vabstol=1e-12 iabstol=1e-18 gmin=1e-15 temp=27
saveOpts options save=selected

// DUT: module ecfet_v2(In, Out, IGsc, Rmem); defaults = Python twin defaults.
X1 (n_in 0 n_igsc n_rmem) ecfet_v2

// read path: 10 mV across In-Out (the paper reads at 0.1 V; the
// models' state does not depend on the read bias)
vread (n_in 0) vsource dc=0.01 type=dc

// gate drive: intended so a positive value flows INTO the IGsc pin (potentiation)
igate (0 n_igsc) isource type=pwl wave=[ 0 0 0.01 0 0.010001 5e-11 0.02 5e-11 \
    0.020001 0 47100 0 ]
Rshunt (n_igsc 0) resistor r=1G   // DC path for the IGsc sense node

// initial state (n_nv = 1/Rinit (also forced by the .va's analysis("ic") branch))
ic X1.n_nv=0.000227272727273 X1.n_v1=0 X1.n_v2=0 X1.n_v3=0

// maxstep = the twin's coarse hold step; the twin uses 0.01 s steps up to 300 s.
tran tran stop=47100 maxstep=60 errpreset=conservative ic=node

save n_rmem X1.n_nv X1.n_v1 X1.n_v2 X1.n_v3 X1.n_stdp vread:p X1:IGsc
