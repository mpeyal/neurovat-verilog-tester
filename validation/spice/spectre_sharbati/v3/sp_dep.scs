// sp_dep.scs - GENERATED by validation/paper/make_decks_paper.py; do not edit.
// Paper overlay deck (Sharbati et al., Adv. Mater. 30, 1802353 (2018)): ecfet_v3 under 'sp_dep'
//   one -50 pA / 10 ms pulse at 5 s (Fig. 3b), then 200 s of relaxation
// stimulus set sharbati-1 (d133e46493727894), t_stop 205 s
//
// Run (writes sp_dep.raw/tran.tran in PSF-ascii):
//   spectre +escchars -format psfascii -raw sp_dep.raw +log sp_dep.log sp_dep.scs
// then import with validation/paper/scrub_paper.py (see validation/README.md).

simulator lang=spectre
global 0

ahdl_include "../../../../verilog/ecfet_v3.va"

simOpts options reltol=1e-6 vabstol=1e-12 iabstol=1e-18 gmin=1e-15 temp=27
saveOpts options save=selected

// DUT: module ecfet_v3(In, Out, IGsc, Rmem); defaults = Python twin defaults.
X1 (n_in 0 n_igsc n_rmem) ecfet_v3

// read path: 10 mV across In-Out (the paper reads at 0.1 V; the
// models' state does not depend on the read bias)
vread (n_in 0) vsource dc=0.01 type=dc

// gate drive: intended so a positive value flows INTO the IGsc pin (potentiation)
igate (0 n_igsc) isource type=pwl wave=[ 0 0 5 0 5.000001 -5e-11 5.01 -5e-11 \
    5.010001 0 205 0 ]
Rshunt (n_igsc 0) resistor r=1G   // DC path for the IGsc sense node

// initial state (n_x and the pools are idt(rate, ic) nodes seeded inside the .va)
// no ic statement: x_init = 0.199853851 (from Rinit)

tran tran stop=205 maxstep=0.005 errpreset=conservative ic=node

save n_rmem X1.n_x X1.n_v1 X1.n_v2 X1.n_v3 X1.n_stdp vread:p X1:IGsc
