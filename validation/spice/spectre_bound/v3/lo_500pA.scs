// lo_500pA.scs - GENERATED by validation/bound/bound_check.py; do not edit.
// v3 rail check: Rinit 8000 ohm: 30 x -500 pA into the lower rail, then 20 x +500 pA
// stimulus set bound-1 (e3737f775df1e214), t_stop 2.8 s

simulator lang=spectre
global 0

ahdl_include "../../../../verilog/ecfet_v3.va"

simOpts options reltol=1e-6 vabstol=1e-12 iabstol=1e-18 gmin=1e-15 temp=27
saveOpts options save=selected

X1 (n_in 0 n_igsc n_rmem) ecfet_v3 Rinit=8000
vread (n_in 0) vsource dc=0.01 type=dc
igate (0 n_igsc) isource type=pwl wave=[ 0 0 0.1 0 0.100001 -5e-10 0.11 -5e-10 \
    0.110001 0 0.15 0 0.150001 -5e-10 0.16 -5e-10 \
    0.160001 0 0.2 0 0.200001 -5e-10 0.21 -5e-10 \
    0.210001 0 0.25 0 0.250001 -5e-10 0.26 -5e-10 \
    0.260001 0 0.3 0 0.300001 -5e-10 0.31 -5e-10 \
    0.310001 0 0.35 0 0.350001 -5e-10 0.36 -5e-10 \
    0.360001 0 0.4 0 0.400001 -5e-10 0.41 -5e-10 \
    0.410001 0 0.45 0 0.450001 -5e-10 0.46 -5e-10 \
    0.460001 0 0.5 0 0.500001 -5e-10 0.51 -5e-10 \
    0.510001 0 0.55 0 0.550001 -5e-10 0.56 -5e-10 \
    0.560001 0 0.6 0 0.600001 -5e-10 0.61 -5e-10 \
    0.610001 0 0.65 0 0.650001 -5e-10 0.66 -5e-10 \
    0.660001 0 0.7 0 0.700001 -5e-10 0.71 -5e-10 \
    0.710001 0 0.75 0 0.750001 -5e-10 0.76 -5e-10 \
    0.760001 0 0.8 0 0.800001 -5e-10 0.81 -5e-10 \
    0.810001 0 0.85 0 0.850001 -5e-10 0.86 -5e-10 \
    0.860001 0 0.9 0 0.900001 -5e-10 0.91 -5e-10 \
    0.910001 0 0.95 0 0.950001 -5e-10 0.96 -5e-10 \
    0.960001 0 1 0 1.000001 -5e-10 1.01 -5e-10 \
    1.010001 0 1.05 0 1.050001 -5e-10 1.06 -5e-10 \
    1.060001 0 1.1 0 1.100001 -5e-10 1.11 -5e-10 \
    1.110001 0 1.15 0 1.150001 -5e-10 1.16 -5e-10 \
    1.160001 0 1.2 0 1.200001 -5e-10 1.21 -5e-10 \
    1.210001 0 1.25 0 1.250001 -5e-10 1.26 -5e-10 \
    1.260001 0 1.3 0 1.300001 -5e-10 1.31 -5e-10 \
    1.310001 0 1.35 0 1.350001 -5e-10 1.36 -5e-10 \
    1.360001 0 1.4 0 1.400001 -5e-10 1.41 -5e-10 \
    1.410001 0 1.45 0 1.450001 -5e-10 1.46 -5e-10 \
    1.460001 0 1.5 0 1.500001 -5e-10 1.51 -5e-10 \
    1.510001 0 1.55 0 1.550001 -5e-10 1.56 -5e-10 \
    1.560001 0 1.6 0 1.600001 5e-10 1.61 5e-10 \
    1.610001 0 1.65 0 1.650001 5e-10 1.66 5e-10 \
    1.660001 0 1.7 0 1.700001 5e-10 1.71 5e-10 \
    1.710001 0 1.75 0 1.750001 5e-10 1.76 5e-10 \
    1.760001 0 1.8 0 1.800001 5e-10 1.81 5e-10 \
    1.810001 0 1.85 0 1.850001 5e-10 1.86 5e-10 \
    1.860001 0 1.9 0 1.900001 5e-10 1.91 5e-10 \
    1.910001 0 1.95 0 1.950001 5e-10 1.96 5e-10 \
    1.960001 0 2 0 2.000001 5e-10 2.01 5e-10 \
    2.010001 0 2.05 0 2.050001 5e-10 2.06 5e-10 \
    2.060001 0 2.1 0 2.100001 5e-10 2.11 5e-10 \
    2.110001 0 2.15 0 2.150001 5e-10 2.16 5e-10 \
    2.160001 0 2.2 0 2.200001 5e-10 2.21 5e-10 \
    2.210001 0 2.25 0 2.250001 5e-10 2.26 5e-10 \
    2.260001 0 2.3 0 2.300001 5e-10 2.31 5e-10 \
    2.310001 0 2.35 0 2.350001 5e-10 2.36 5e-10 \
    2.360001 0 2.4 0 2.400001 5e-10 2.41 5e-10 \
    2.410001 0 2.45 0 2.450001 5e-10 2.46 5e-10 \
    2.460001 0 2.5 0 2.500001 5e-10 2.51 5e-10 \
    2.510001 0 2.55 0 2.550001 5e-10 2.56 5e-10 \
    2.560001 0 2.8 0 ]
Rshunt (n_igsc 0) resistor r=1G

tran tran stop=2.8 maxstep=0.005 errpreset=conservative ic=node

save n_rmem X1.n_x X1.n_v1 X1.n_v2 X1.n_v3 X1.n_stdp vread:p X1:IGsc
