// lo_50pA.scs - GENERATED by validation/bound/bound_check.py; do not edit.
// v3 rail check: Rinit 8000 ohm: 120 x -50 pA into the lower rail, then 40 x +50 pA
// stimulus set bound-1 (e3737f775df1e214), t_stop 8.3 s

simulator lang=spectre
global 0

ahdl_include "../../../../verilog/ecfet_v3.va"

simOpts options reltol=1e-6 vabstol=1e-12 iabstol=1e-18 gmin=1e-15 temp=27
saveOpts options save=selected

X1 (n_in 0 n_igsc n_rmem) ecfet_v3 Rinit=8000
vread (n_in 0) vsource dc=0.01 type=dc
igate (0 n_igsc) isource type=pwl wave=[ 0 0 0.1 0 0.100001 -5e-11 0.11 -5e-11 \
    0.110001 0 0.15 0 0.150001 -5e-11 0.16 -5e-11 \
    0.160001 0 0.2 0 0.200001 -5e-11 0.21 -5e-11 \
    0.210001 0 0.25 0 0.250001 -5e-11 0.26 -5e-11 \
    0.260001 0 0.3 0 0.300001 -5e-11 0.31 -5e-11 \
    0.310001 0 0.35 0 0.350001 -5e-11 0.36 -5e-11 \
    0.360001 0 0.4 0 0.400001 -5e-11 0.41 -5e-11 \
    0.410001 0 0.45 0 0.450001 -5e-11 0.46 -5e-11 \
    0.460001 0 0.5 0 0.500001 -5e-11 0.51 -5e-11 \
    0.510001 0 0.55 0 0.550001 -5e-11 0.56 -5e-11 \
    0.560001 0 0.6 0 0.600001 -5e-11 0.61 -5e-11 \
    0.610001 0 0.65 0 0.650001 -5e-11 0.66 -5e-11 \
    0.660001 0 0.7 0 0.700001 -5e-11 0.71 -5e-11 \
    0.710001 0 0.75 0 0.750001 -5e-11 0.76 -5e-11 \
    0.760001 0 0.8 0 0.800001 -5e-11 0.81 -5e-11 \
    0.810001 0 0.85 0 0.850001 -5e-11 0.86 -5e-11 \
    0.860001 0 0.9 0 0.900001 -5e-11 0.91 -5e-11 \
    0.910001 0 0.95 0 0.950001 -5e-11 0.96 -5e-11 \
    0.960001 0 1 0 1.000001 -5e-11 1.01 -5e-11 \
    1.010001 0 1.05 0 1.050001 -5e-11 1.06 -5e-11 \
    1.060001 0 1.1 0 1.100001 -5e-11 1.11 -5e-11 \
    1.110001 0 1.15 0 1.150001 -5e-11 1.16 -5e-11 \
    1.160001 0 1.2 0 1.200001 -5e-11 1.21 -5e-11 \
    1.210001 0 1.25 0 1.250001 -5e-11 1.26 -5e-11 \
    1.260001 0 1.3 0 1.300001 -5e-11 1.31 -5e-11 \
    1.310001 0 1.35 0 1.350001 -5e-11 1.36 -5e-11 \
    1.360001 0 1.4 0 1.400001 -5e-11 1.41 -5e-11 \
    1.410001 0 1.45 0 1.450001 -5e-11 1.46 -5e-11 \
    1.460001 0 1.5 0 1.500001 -5e-11 1.51 -5e-11 \
    1.510001 0 1.55 0 1.550001 -5e-11 1.56 -5e-11 \
    1.560001 0 1.6 0 1.600001 -5e-11 1.61 -5e-11 \
    1.610001 0 1.65 0 1.650001 -5e-11 1.66 -5e-11 \
    1.660001 0 1.7 0 1.700001 -5e-11 1.71 -5e-11 \
    1.710001 0 1.75 0 1.750001 -5e-11 1.76 -5e-11 \
    1.760001 0 1.8 0 1.800001 -5e-11 1.81 -5e-11 \
    1.810001 0 1.85 0 1.850001 -5e-11 1.86 -5e-11 \
    1.860001 0 1.9 0 1.900001 -5e-11 1.91 -5e-11 \
    1.910001 0 1.95 0 1.950001 -5e-11 1.96 -5e-11 \
    1.960001 0 2 0 2.000001 -5e-11 2.01 -5e-11 \
    2.010001 0 2.05 0 2.050001 -5e-11 2.06 -5e-11 \
    2.060001 0 2.1 0 2.100001 -5e-11 2.11 -5e-11 \
    2.110001 0 2.15 0 2.150001 -5e-11 2.16 -5e-11 \
    2.160001 0 2.2 0 2.200001 -5e-11 2.21 -5e-11 \
    2.210001 0 2.25 0 2.250001 -5e-11 2.26 -5e-11 \
    2.260001 0 2.3 0 2.300001 -5e-11 2.31 -5e-11 \
    2.310001 0 2.35 0 2.350001 -5e-11 2.36 -5e-11 \
    2.360001 0 2.4 0 2.400001 -5e-11 2.41 -5e-11 \
    2.410001 0 2.45 0 2.450001 -5e-11 2.46 -5e-11 \
    2.460001 0 2.5 0 2.500001 -5e-11 2.51 -5e-11 \
    2.510001 0 2.55 0 2.550001 -5e-11 2.56 -5e-11 \
    2.560001 0 2.6 0 2.600001 -5e-11 2.61 -5e-11 \
    2.610001 0 2.65 0 2.650001 -5e-11 2.66 -5e-11 \
    2.660001 0 2.7 0 2.700001 -5e-11 2.71 -5e-11 \
    2.710001 0 2.75 0 2.750001 -5e-11 2.76 -5e-11 \
    2.760001 0 2.8 0 2.800001 -5e-11 2.81 -5e-11 \
    2.810001 0 2.85 0 2.850001 -5e-11 2.86 -5e-11 \
    2.860001 0 2.9 0 2.900001 -5e-11 2.91 -5e-11 \
    2.910001 0 2.95 0 2.950001 -5e-11 2.96 -5e-11 \
    2.960001 0 3 0 3.000001 -5e-11 3.01 -5e-11 \
    3.010001 0 3.05 0 3.050001 -5e-11 3.06 -5e-11 \
    3.060001 0 3.1 0 3.100001 -5e-11 3.11 -5e-11 \
    3.110001 0 3.15 0 3.150001 -5e-11 3.16 -5e-11 \
    3.160001 0 3.2 0 3.200001 -5e-11 3.21 -5e-11 \
    3.210001 0 3.25 0 3.250001 -5e-11 3.26 -5e-11 \
    3.260001 0 3.3 0 3.300001 -5e-11 3.31 -5e-11 \
    3.310001 0 3.35 0 3.350001 -5e-11 3.36 -5e-11 \
    3.360001 0 3.4 0 3.400001 -5e-11 3.41 -5e-11 \
    3.410001 0 3.45 0 3.450001 -5e-11 3.46 -5e-11 \
    3.460001 0 3.5 0 3.500001 -5e-11 3.51 -5e-11 \
    3.510001 0 3.55 0 3.550001 -5e-11 3.56 -5e-11 \
    3.560001 0 3.6 0 3.600001 -5e-11 3.61 -5e-11 \
    3.610001 0 3.65 0 3.650001 -5e-11 3.66 -5e-11 \
    3.660001 0 3.7 0 3.700001 -5e-11 3.71 -5e-11 \
    3.710001 0 3.75 0 3.750001 -5e-11 3.76 -5e-11 \
    3.760001 0 3.8 0 3.800001 -5e-11 3.81 -5e-11 \
    3.810001 0 3.85 0 3.850001 -5e-11 3.86 -5e-11 \
    3.860001 0 3.9 0 3.900001 -5e-11 3.91 -5e-11 \
    3.910001 0 3.95 0 3.950001 -5e-11 3.96 -5e-11 \
    3.960001 0 4 0 4.000001 -5e-11 4.01 -5e-11 \
    4.010001 0 4.05 0 4.050001 -5e-11 4.06 -5e-11 \
    4.060001 0 4.1 0 4.100001 -5e-11 4.11 -5e-11 \
    4.110001 0 4.15 0 4.150001 -5e-11 4.16 -5e-11 \
    4.160001 0 4.2 0 4.200001 -5e-11 4.21 -5e-11 \
    4.210001 0 4.25 0 4.250001 -5e-11 4.26 -5e-11 \
    4.260001 0 4.3 0 4.300001 -5e-11 4.31 -5e-11 \
    4.310001 0 4.35 0 4.350001 -5e-11 4.36 -5e-11 \
    4.360001 0 4.4 0 4.400001 -5e-11 4.41 -5e-11 \
    4.410001 0 4.45 0 4.450001 -5e-11 4.46 -5e-11 \
    4.460001 0 4.5 0 4.500001 -5e-11 4.51 -5e-11 \
    4.510001 0 4.55 0 4.550001 -5e-11 4.56 -5e-11 \
    4.560001 0 4.6 0 4.600001 -5e-11 4.61 -5e-11 \
    4.610001 0 4.65 0 4.650001 -5e-11 4.66 -5e-11 \
    4.660001 0 4.7 0 4.700001 -5e-11 4.71 -5e-11 \
    4.710001 0 4.75 0 4.750001 -5e-11 4.76 -5e-11 \
    4.760001 0 4.8 0 4.800001 -5e-11 4.81 -5e-11 \
    4.810001 0 4.85 0 4.850001 -5e-11 4.86 -5e-11 \
    4.860001 0 4.9 0 4.900001 -5e-11 4.91 -5e-11 \
    4.910001 0 4.95 0 4.950001 -5e-11 4.96 -5e-11 \
    4.960001 0 5 0 5.000001 -5e-11 5.01 -5e-11 \
    5.010001 0 5.05 0 5.050001 -5e-11 5.06 -5e-11 \
    5.060001 0 5.1 0 5.100001 -5e-11 5.11 -5e-11 \
    5.110001 0 5.15 0 5.150001 -5e-11 5.16 -5e-11 \
    5.160001 0 5.2 0 5.200001 -5e-11 5.21 -5e-11 \
    5.210001 0 5.25 0 5.250001 -5e-11 5.26 -5e-11 \
    5.260001 0 5.3 0 5.300001 -5e-11 5.31 -5e-11 \
    5.310001 0 5.35 0 5.350001 -5e-11 5.36 -5e-11 \
    5.360001 0 5.4 0 5.400001 -5e-11 5.41 -5e-11 \
    5.410001 0 5.45 0 5.450001 -5e-11 5.46 -5e-11 \
    5.460001 0 5.5 0 5.500001 -5e-11 5.51 -5e-11 \
    5.510001 0 5.55 0 5.550001 -5e-11 5.56 -5e-11 \
    5.560001 0 5.6 0 5.600001 -5e-11 5.61 -5e-11 \
    5.610001 0 5.65 0 5.650001 -5e-11 5.66 -5e-11 \
    5.660001 0 5.7 0 5.700001 -5e-11 5.71 -5e-11 \
    5.710001 0 5.75 0 5.750001 -5e-11 5.76 -5e-11 \
    5.760001 0 5.8 0 5.800001 -5e-11 5.81 -5e-11 \
    5.810001 0 5.85 0 5.850001 -5e-11 5.86 -5e-11 \
    5.860001 0 5.9 0 5.900001 -5e-11 5.91 -5e-11 \
    5.910001 0 5.95 0 5.950001 -5e-11 5.96 -5e-11 \
    5.960001 0 6 0 6.000001 -5e-11 6.01 -5e-11 \
    6.010001 0 6.05 0 6.050001 -5e-11 6.06 -5e-11 \
    6.060001 0 6.1 0 6.100001 5e-11 6.11 5e-11 \
    6.110001 0 6.15 0 6.150001 5e-11 6.16 5e-11 \
    6.160001 0 6.2 0 6.200001 5e-11 6.21 5e-11 \
    6.210001 0 6.25 0 6.250001 5e-11 6.26 5e-11 \
    6.260001 0 6.3 0 6.300001 5e-11 6.31 5e-11 \
    6.310001 0 6.35 0 6.350001 5e-11 6.36 5e-11 \
    6.360001 0 6.4 0 6.400001 5e-11 6.41 5e-11 \
    6.410001 0 6.45 0 6.450001 5e-11 6.46 5e-11 \
    6.460001 0 6.5 0 6.500001 5e-11 6.51 5e-11 \
    6.510001 0 6.55 0 6.550001 5e-11 6.56 5e-11 \
    6.560001 0 6.6 0 6.600001 5e-11 6.61 5e-11 \
    6.610001 0 6.65 0 6.650001 5e-11 6.66 5e-11 \
    6.660001 0 6.7 0 6.700001 5e-11 6.71 5e-11 \
    6.710001 0 6.75 0 6.750001 5e-11 6.76 5e-11 \
    6.760001 0 6.8 0 6.800001 5e-11 6.81 5e-11 \
    6.810001 0 6.85 0 6.850001 5e-11 6.86 5e-11 \
    6.860001 0 6.9 0 6.900001 5e-11 6.91 5e-11 \
    6.910001 0 6.95 0 6.950001 5e-11 6.96 5e-11 \
    6.960001 0 7 0 7.000001 5e-11 7.01 5e-11 \
    7.010001 0 7.05 0 7.050001 5e-11 7.06 5e-11 \
    7.060001 0 7.1 0 7.100001 5e-11 7.11 5e-11 \
    7.110001 0 7.15 0 7.150001 5e-11 7.16 5e-11 \
    7.160001 0 7.2 0 7.200001 5e-11 7.21 5e-11 \
    7.210001 0 7.25 0 7.250001 5e-11 7.26 5e-11 \
    7.260001 0 7.3 0 7.300001 5e-11 7.31 5e-11 \
    7.310001 0 7.35 0 7.350001 5e-11 7.36 5e-11 \
    7.360001 0 7.4 0 7.400001 5e-11 7.41 5e-11 \
    7.410001 0 7.45 0 7.450001 5e-11 7.46 5e-11 \
    7.460001 0 7.5 0 7.500001 5e-11 7.51 5e-11 \
    7.510001 0 7.55 0 7.550001 5e-11 7.56 5e-11 \
    7.560001 0 7.6 0 7.600001 5e-11 7.61 5e-11 \
    7.610001 0 7.65 0 7.650001 5e-11 7.66 5e-11 \
    7.660001 0 7.7 0 7.700001 5e-11 7.71 5e-11 \
    7.710001 0 7.75 0 7.750001 5e-11 7.76 5e-11 \
    7.760001 0 7.8 0 7.800001 5e-11 7.81 5e-11 \
    7.810001 0 7.85 0 7.850001 5e-11 7.86 5e-11 \
    7.860001 0 7.9 0 7.900001 5e-11 7.91 5e-11 \
    7.910001 0 7.95 0 7.950001 5e-11 7.96 5e-11 \
    7.960001 0 8 0 8.000001 5e-11 8.01 5e-11 \
    8.010001 0 8.05 0 8.050001 5e-11 8.06 5e-11 \
    8.060001 0 8.3 0 ]
Rshunt (n_igsc 0) resistor r=1G

tran tran stop=8.3 maxstep=0.005 errpreset=conservative ic=node

save n_rmem X1.n_x X1.n_v1 X1.n_v2 X1.n_v3 X1.n_stdp vread:p X1:IGsc
