// s2_vteam.scs - GENERATED by validation/vteam/make_decks.py; do not edit.
// vteam-1 validation deck: VTEAM memristor (vteam) under 's2_vteam'
//   MemTorch-comparison S2 (faster ON): 10 x +1.0 V / 10 ns, then 10 x -0.25 V / 2 ns (10.4 % of d each), from ON, reads
// stimulus set vteam-1 (387eca88c0b9d6f4), t_stop 3.27e-07 s,
// 20 read plateau(s) at -0.1 V, maxstep 1e-10 s
//
// Model: S. Kvatinsky et al., "VTEAM: A General Model for Voltage-Controlled
// Memristors", IEEE TCAS-II 62(8), 2015; MemTorch 1.1.6 variant (see vteam.va).
//
// Run (writes s2_vteam.raw/tran.tran.tran in PSF-ascii with Spectre 24.1):
//   spectre +escchars -format psfascii -raw s2_vteam.raw +log s2_vteam.log s2_vteam.scs
// then import with validation/vteam/scrub.py.

simulator lang=spectre
global 0

ahdl_include "../../../verilog/vteam.va"

simOpts options reltol=1e-05 vabstol=1e-9 iabstol=1e-15 gmin=1e-15
saveOpts options save=selected

X1 (n_p 0) vteam

// V(p,n): PWL with exactly the twin's points
vin (n_p 0) vsource type=pwl wave=[ 0 0 1e-09 0 1.05e-09 1 1.1e-08 1 \
    1.105e-08 0 1.405e-08 0 1.41e-08 -0.1 1.805e-08 -0.1 \
    1.81e-08 0 2.105e-08 0 2.11e-08 1 3.105e-08 1 \
    3.11e-08 0 3.41e-08 0 3.415e-08 -0.1 3.81e-08 -0.1 \
    3.815e-08 0 4.11e-08 0 4.115e-08 1 5.11e-08 1 \
    5.115e-08 0 5.415e-08 0 5.42e-08 -0.1 5.815e-08 -0.1 \
    5.82e-08 0 6.115e-08 0 6.12e-08 1 7.115e-08 1 \
    7.12e-08 0 7.42e-08 0 7.425e-08 -0.1 7.82e-08 -0.1 \
    7.825e-08 0 8.12e-08 0 8.125e-08 1 9.12e-08 1 \
    9.125e-08 0 9.425e-08 0 9.43e-08 -0.1 9.825e-08 -0.1 \
    9.83e-08 0 1.0125e-07 0 1.013e-07 1 1.1125e-07 1 \
    1.113e-07 0 1.143e-07 0 1.1435e-07 -0.1 1.183e-07 -0.1 \
    1.1835e-07 0 1.213e-07 0 1.2135e-07 1 1.313e-07 1 \
    1.3135e-07 0 1.3435e-07 0 1.344e-07 -0.1 1.3835e-07 -0.1 \
    1.384e-07 0 1.4135e-07 0 1.414e-07 1 1.5135e-07 1 \
    1.514e-07 0 1.544e-07 0 1.5445e-07 -0.1 1.584e-07 -0.1 \
    1.5845e-07 0 1.614e-07 0 1.6145e-07 1 1.714e-07 1 \
    1.7145e-07 0 1.7445e-07 0 1.745e-07 -0.1 1.7845e-07 -0.1 \
    1.785e-07 0 1.8145e-07 0 1.815e-07 1 1.9145e-07 1 \
    1.915e-07 0 1.945e-07 0 1.9455e-07 -0.1 1.985e-07 -0.1 \
    1.9855e-07 0 2.015e-07 0 2.0155e-07 -0.25 2.035e-07 -0.25 \
    2.0355e-07 0 2.0655e-07 0 2.066e-07 -0.1 2.1055e-07 -0.1 \
    2.106e-07 0 2.1355e-07 0 2.136e-07 -0.25 2.1555e-07 -0.25 \
    2.156e-07 0 2.186e-07 0 2.1865e-07 -0.1 2.226e-07 -0.1 \
    2.2265e-07 0 2.256e-07 0 2.2565e-07 -0.25 2.276e-07 -0.25 \
    2.2765e-07 0 2.3065e-07 0 2.307e-07 -0.1 2.3465e-07 -0.1 \
    2.347e-07 0 2.3765e-07 0 2.377e-07 -0.25 2.3965e-07 -0.25 \
    2.397e-07 0 2.427e-07 0 2.4275e-07 -0.1 2.467e-07 -0.1 \
    2.4675e-07 0 2.497e-07 0 2.4975e-07 -0.25 2.517e-07 -0.25 \
    2.5175e-07 0 2.5475e-07 0 2.548e-07 -0.1 2.5875e-07 -0.1 \
    2.588e-07 0 2.6175e-07 0 2.618e-07 -0.25 2.6375e-07 -0.25 \
    2.638e-07 0 2.668e-07 0 2.6685e-07 -0.1 2.708e-07 -0.1 \
    2.7085e-07 0 2.738e-07 0 2.7385e-07 -0.25 2.758e-07 -0.25 \
    2.7585e-07 0 2.7885e-07 0 2.789e-07 -0.1 2.8285e-07 -0.1 \
    2.829e-07 0 2.8585e-07 0 2.859e-07 -0.25 2.8785e-07 -0.25 \
    2.879e-07 0 2.909e-07 0 2.9095e-07 -0.1 2.949e-07 -0.1 \
    2.9495e-07 0 2.979e-07 0 2.9795e-07 -0.25 2.999e-07 -0.25 \
    2.9995e-07 0 3.0295e-07 0 3.03e-07 -0.1 3.0695e-07 -0.1 \
    3.07e-07 0 3.0995e-07 0 3.1e-07 -0.25 3.1195e-07 -0.25 \
    3.12e-07 0 3.15e-07 0 3.1505e-07 -0.1 3.19e-07 -0.1 \
    3.1905e-07 0 3.22e-07 0 3.27e-07 0 ]

tran tran stop=3.27e-07 maxstep=1e-10 errpreset=conservative

save n_p X1:p X1.ws
