// amplitude_sweep.scs - GENERATED by validation/vteam/make_decks.py; do not edit.
// vteam-1 validation deck: VTEAM memristor (vteam) under 'amplitude_sweep'
//   from ON: 10 ns OFF pulses of +0.2..+1.0 V, then 10 ns ON pulses of -0.21..-0.25 V (the last reaches x = 0), each read
// stimulus set vteam-1 (3103a410f6b1223a), t_stop 2.065e-07 s,
// 10 read plateau(s) at -0.1 V, maxstep 1e-10 s
//
// Model: S. Kvatinsky et al., "VTEAM: A General Model for Voltage-Controlled
// Memristors", IEEE TCAS-II 62(8), 2015; MemTorch 1.1.6 variant (see vteam.va).
//
// Run (writes amplitude_sweep.raw/tran.tran.tran in PSF-ascii with Spectre 24.1):
//   spectre +escchars -format psfascii -raw amplitude_sweep.raw +log amplitude_sweep.log amplitude_sweep.scs
// then import with validation/vteam/scrub.py.

simulator lang=spectre
global 0

ahdl_include "../../../verilog/vteam.va"

simOpts options reltol=1e-05 vabstol=1e-9 iabstol=1e-15 gmin=1e-15
saveOpts options save=selected

X1 (n_p 0) vteam

// V(p,n): PWL with exactly the twin's points
vin (n_p 0) vsource type=pwl wave=[ 0 0 1e-09 0 1.05e-09 0.2 1.1e-08 0.2 \
    1.105e-08 0 1.405e-08 0 1.41e-08 -0.1 1.805e-08 -0.1 \
    1.81e-08 0 2.105e-08 0 2.11e-08 0.4 3.105e-08 0.4 \
    3.11e-08 0 3.41e-08 0 3.415e-08 -0.1 3.81e-08 -0.1 \
    3.815e-08 0 4.11e-08 0 4.115e-08 0.6 5.11e-08 0.6 \
    5.115e-08 0 5.415e-08 0 5.42e-08 -0.1 5.815e-08 -0.1 \
    5.82e-08 0 6.115e-08 0 6.12e-08 0.8 7.115e-08 0.8 \
    7.12e-08 0 7.42e-08 0 7.425e-08 -0.1 7.82e-08 -0.1 \
    7.825e-08 0 8.12e-08 0 8.125e-08 1 9.12e-08 1 \
    9.125e-08 0 9.425e-08 0 9.43e-08 -0.1 9.825e-08 -0.1 \
    9.83e-08 0 1.0125e-07 0 1.013e-07 -0.21 1.1125e-07 -0.21 \
    1.113e-07 0 1.143e-07 0 1.1435e-07 -0.1 1.183e-07 -0.1 \
    1.1835e-07 0 1.213e-07 0 1.2135e-07 -0.22 1.313e-07 -0.22 \
    1.3135e-07 0 1.3435e-07 0 1.344e-07 -0.1 1.3835e-07 -0.1 \
    1.384e-07 0 1.4135e-07 0 1.414e-07 -0.23 1.5135e-07 -0.23 \
    1.514e-07 0 1.544e-07 0 1.5445e-07 -0.1 1.584e-07 -0.1 \
    1.5845e-07 0 1.614e-07 0 1.6145e-07 -0.24 1.714e-07 -0.24 \
    1.7145e-07 0 1.7445e-07 0 1.745e-07 -0.1 1.7845e-07 -0.1 \
    1.785e-07 0 1.8145e-07 0 1.815e-07 -0.25 1.9145e-07 -0.25 \
    1.915e-07 0 1.945e-07 0 1.9455e-07 -0.1 1.985e-07 -0.1 \
    1.9855e-07 0 2.015e-07 0 2.065e-07 0 ]

tran tran stop=2.065e-07 maxstep=1e-10 errpreset=conservative

save n_p X1:p X1.ws
