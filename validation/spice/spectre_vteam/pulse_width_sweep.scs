// pulse_width_sweep.scs - GENERATED by validation/vteam/make_decks.py; do not edit.
// vteam-1 validation deck: VTEAM memristor (vteam) under 'pulse_width_sweep'
//   from ON: +0.8 V pulses of 1/2/5/10/20 ns, then -0.23 V pulses of 1/2/5/10/20 ns (reaches x = 0), each read
// stimulus set vteam-1 (3103a410f6b1223a), t_stop 1.825e-07 s,
// 10 read plateau(s) at -0.1 V, maxstep 1e-10 s
//
// Model: S. Kvatinsky et al., "VTEAM: A General Model for Voltage-Controlled
// Memristors", IEEE TCAS-II 62(8), 2015; MemTorch 1.1.6 variant (see vteam.va).
//
// Run (writes pulse_width_sweep.raw/tran.tran.tran in PSF-ascii with Spectre 24.1):
//   spectre +escchars -format psfascii -raw pulse_width_sweep.raw +log pulse_width_sweep.log pulse_width_sweep.scs
// then import with validation/vteam/scrub.py.

simulator lang=spectre
global 0

ahdl_include "../../../verilog/vteam.va"

simOpts options reltol=1e-05 vabstol=1e-9 iabstol=1e-15 gmin=1e-15
saveOpts options save=selected

X1 (n_p 0) vteam

// V(p,n): PWL with exactly the twin's points
vin (n_p 0) vsource type=pwl wave=[ 0 0 1e-09 0 1.05e-09 0.8 2e-09 0.8 \
    2.05e-09 0 5.05e-09 0 5.1e-09 -0.1 9.05e-09 -0.1 \
    9.1e-09 0 1.205e-08 0 1.21e-08 0.8 1.405e-08 0.8 \
    1.41e-08 0 1.71e-08 0 1.715e-08 -0.1 2.11e-08 -0.1 \
    2.115e-08 0 2.41e-08 0 2.415e-08 0.8 2.91e-08 0.8 \
    2.915e-08 0 3.215e-08 0 3.22e-08 -0.1 3.615e-08 -0.1 \
    3.62e-08 0 3.915e-08 0 3.92e-08 0.8 4.915e-08 0.8 \
    4.92e-08 0 5.22e-08 0 5.225e-08 -0.1 5.62e-08 -0.1 \
    5.625e-08 0 5.92e-08 0 5.925e-08 0.8 7.92e-08 0.8 \
    7.925e-08 0 8.225e-08 0 8.23e-08 -0.1 8.625e-08 -0.1 \
    8.63e-08 0 8.925e-08 0 8.93e-08 -0.23 9.025e-08 -0.23 \
    9.03e-08 0 9.33e-08 0 9.335e-08 -0.1 9.73e-08 -0.1 \
    9.735e-08 0 1.003e-07 0 1.0035e-07 -0.23 1.023e-07 -0.23 \
    1.0235e-07 0 1.0535e-07 0 1.054e-07 -0.1 1.0935e-07 -0.1 \
    1.094e-07 0 1.1235e-07 0 1.124e-07 -0.23 1.1735e-07 -0.23 \
    1.174e-07 0 1.204e-07 0 1.2045e-07 -0.1 1.244e-07 -0.1 \
    1.2445e-07 0 1.274e-07 0 1.2745e-07 -0.23 1.374e-07 -0.23 \
    1.3745e-07 0 1.4045e-07 0 1.405e-07 -0.1 1.4445e-07 -0.1 \
    1.445e-07 0 1.4745e-07 0 1.475e-07 -0.23 1.6745e-07 -0.23 \
    1.675e-07 0 1.705e-07 0 1.7055e-07 -0.1 1.745e-07 -0.1 \
    1.7455e-07 0 1.775e-07 0 1.825e-07 0 ]

tran tran stop=1.825e-07 maxstep=1e-10 errpreset=conservative

save n_p X1:p X1.ws
