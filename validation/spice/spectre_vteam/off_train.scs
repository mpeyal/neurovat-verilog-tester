// off_train.scs - GENERATED by validation/vteam/make_decks.py; do not edit.
// vteam-1 validation deck: VTEAM memristor (vteam) under 'off_train'
//   from ON (x = 0): 20 x +0.8 V / 10 ns OFF pulses (6.5 % of d each, reaches the x = d bound at pulse 16), 10 ns gaps, -0.1 V read in every gap
// stimulus set vteam-1 (387eca88c0b9d6f4), t_stop 4.07e-07 s,
// 20 read plateau(s) at -0.1 V, maxstep 1e-10 s
//
// Model: S. Kvatinsky et al., "VTEAM: A General Model for Voltage-Controlled
// Memristors", IEEE TCAS-II 62(8), 2015; MemTorch 1.1.6 variant (see vteam.va).
//
// Run (writes off_train.raw/tran.tran.tran in PSF-ascii with Spectre 24.1):
//   spectre +escchars -format psfascii -raw off_train.raw +log off_train.log off_train.scs
// then import with validation/vteam/scrub.py.

simulator lang=spectre
global 0

ahdl_include "../../../verilog/vteam.va"

simOpts options reltol=1e-05 vabstol=1e-9 iabstol=1e-15 gmin=1e-15
saveOpts options save=selected

X1 (n_p 0) vteam

// V(p,n): PWL with exactly the twin's points
vin (n_p 0) vsource type=pwl wave=[ 0 0 1e-09 0 1.05e-09 0.8 1.1e-08 0.8 \
    1.105e-08 0 1.405e-08 0 1.41e-08 -0.1 1.805e-08 -0.1 \
    1.81e-08 0 2.105e-08 0 2.11e-08 0.8 3.105e-08 0.8 \
    3.11e-08 0 3.41e-08 0 3.415e-08 -0.1 3.81e-08 -0.1 \
    3.815e-08 0 4.11e-08 0 4.115e-08 0.8 5.11e-08 0.8 \
    5.115e-08 0 5.415e-08 0 5.42e-08 -0.1 5.815e-08 -0.1 \
    5.82e-08 0 6.115e-08 0 6.12e-08 0.8 7.115e-08 0.8 \
    7.12e-08 0 7.42e-08 0 7.425e-08 -0.1 7.82e-08 -0.1 \
    7.825e-08 0 8.12e-08 0 8.125e-08 0.8 9.12e-08 0.8 \
    9.125e-08 0 9.425e-08 0 9.43e-08 -0.1 9.825e-08 -0.1 \
    9.83e-08 0 1.0125e-07 0 1.013e-07 0.8 1.1125e-07 0.8 \
    1.113e-07 0 1.143e-07 0 1.1435e-07 -0.1 1.183e-07 -0.1 \
    1.1835e-07 0 1.213e-07 0 1.2135e-07 0.8 1.313e-07 0.8 \
    1.3135e-07 0 1.3435e-07 0 1.344e-07 -0.1 1.3835e-07 -0.1 \
    1.384e-07 0 1.4135e-07 0 1.414e-07 0.8 1.5135e-07 0.8 \
    1.514e-07 0 1.544e-07 0 1.5445e-07 -0.1 1.584e-07 -0.1 \
    1.5845e-07 0 1.614e-07 0 1.6145e-07 0.8 1.714e-07 0.8 \
    1.7145e-07 0 1.7445e-07 0 1.745e-07 -0.1 1.7845e-07 -0.1 \
    1.785e-07 0 1.8145e-07 0 1.815e-07 0.8 1.9145e-07 0.8 \
    1.915e-07 0 1.945e-07 0 1.9455e-07 -0.1 1.985e-07 -0.1 \
    1.9855e-07 0 2.015e-07 0 2.0155e-07 0.8 2.115e-07 0.8 \
    2.1155e-07 0 2.1455e-07 0 2.146e-07 -0.1 2.1855e-07 -0.1 \
    2.186e-07 0 2.2155e-07 0 2.216e-07 0.8 2.3155e-07 0.8 \
    2.316e-07 0 2.346e-07 0 2.3465e-07 -0.1 2.386e-07 -0.1 \
    2.3865e-07 0 2.416e-07 0 2.4165e-07 0.8 2.516e-07 0.8 \
    2.5165e-07 0 2.5465e-07 0 2.547e-07 -0.1 2.5865e-07 -0.1 \
    2.587e-07 0 2.6165e-07 0 2.617e-07 0.8 2.7165e-07 0.8 \
    2.717e-07 0 2.747e-07 0 2.7475e-07 -0.1 2.787e-07 -0.1 \
    2.7875e-07 0 2.817e-07 0 2.8175e-07 0.8 2.917e-07 0.8 \
    2.9175e-07 0 2.9475e-07 0 2.948e-07 -0.1 2.9875e-07 -0.1 \
    2.988e-07 0 3.0175e-07 0 3.018e-07 0.8 3.1175e-07 0.8 \
    3.118e-07 0 3.148e-07 0 3.1485e-07 -0.1 3.188e-07 -0.1 \
    3.1885e-07 0 3.218e-07 0 3.2185e-07 0.8 3.318e-07 0.8 \
    3.3185e-07 0 3.3485e-07 0 3.349e-07 -0.1 3.3885e-07 -0.1 \
    3.389e-07 0 3.4185e-07 0 3.419e-07 0.8 3.5185e-07 0.8 \
    3.519e-07 0 3.549e-07 0 3.5495e-07 -0.1 3.589e-07 -0.1 \
    3.5895e-07 0 3.619e-07 0 3.6195e-07 0.8 3.719e-07 0.8 \
    3.7195e-07 0 3.7495e-07 0 3.75e-07 -0.1 3.7895e-07 -0.1 \
    3.79e-07 0 3.8195e-07 0 3.82e-07 0.8 3.9195e-07 0.8 \
    3.92e-07 0 3.95e-07 0 3.9505e-07 -0.1 3.99e-07 -0.1 \
    3.9905e-07 0 4.02e-07 0 4.07e-07 0 ]

tran tran stop=4.07e-07 maxstep=1e-10 errpreset=conservative

save n_p X1:p X1.ws
