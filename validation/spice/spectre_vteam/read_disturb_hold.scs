// read_disturb_hold.scs - GENERATED by validation/vteam/make_decks.py; do not edit.
// vteam-1 validation deck: VTEAM memristor (vteam) under 'read_disturb_hold'
//   6 x +0.8 V / 10 ns from ON, read, 100 ns hold, read, then 5 x 5 ns stress at +0.01/-0.1/-0.19 V (dead zone) and +0.03/-0.21 V (just past v_off / v_on), each group read
// stimulus set vteam-1 (3103a410f6b1223a), t_stop 5.226e-07 s,
// 7 read plateau(s) at -0.1 V, maxstep 1e-10 s
//
// Model: S. Kvatinsky et al., "VTEAM: A General Model for Voltage-Controlled
// Memristors", IEEE TCAS-II 62(8), 2015; MemTorch 1.1.6 variant (see vteam.va).
//
// Run (writes read_disturb_hold.raw/tran.tran.tran in PSF-ascii with Spectre 24.1):
//   spectre +escchars -format psfascii -raw read_disturb_hold.raw +log read_disturb_hold.log read_disturb_hold.scs
// then import with validation/vteam/scrub.py.

simulator lang=spectre
global 0

ahdl_include "../../../verilog/vteam.va"

simOpts options reltol=1e-05 vabstol=1e-9 iabstol=1e-15 gmin=1e-15
saveOpts options save=selected

X1 (n_p 0) vteam

// V(p,n): PWL with exactly the twin's points
vin (n_p 0) vsource type=pwl wave=[ 0 0 1e-09 0 1.05e-09 0.8 1.1e-08 0.8 \
    1.105e-08 0 2.1e-08 0 2.105e-08 0.8 3.1e-08 0.8 \
    3.105e-08 0 4.1e-08 0 4.105e-08 0.8 5.1e-08 0.8 \
    5.105e-08 0 6.1e-08 0 6.105e-08 0.8 7.1e-08 0.8 \
    7.105e-08 0 8.1e-08 0 8.105e-08 0.8 9.1e-08 0.8 \
    9.105e-08 0 1.01e-07 0 1.0105e-07 0.8 1.11e-07 0.8 \
    1.1105e-07 0 1.21e-07 0 1.22e-07 0 1.2205e-07 -0.1 \
    1.26e-07 -0.1 1.2605e-07 0 2.2605e-07 0 2.2705e-07 0 \
    2.271e-07 -0.1 2.3105e-07 -0.1 2.311e-07 0 2.361e-07 0 \
    2.3615e-07 0.01 2.411e-07 0.01 2.4115e-07 0 2.4615e-07 0 \
    2.462e-07 0.01 2.5115e-07 0.01 2.512e-07 0 2.562e-07 0 \
    2.5625e-07 0.01 2.612e-07 0.01 2.6125e-07 0 2.6625e-07 0 \
    2.663e-07 0.01 2.7125e-07 0.01 2.713e-07 0 2.763e-07 0 \
    2.7635e-07 0.01 2.813e-07 0.01 2.8135e-07 0 2.8435e-07 0 \
    2.844e-07 -0.1 2.8835e-07 -0.1 2.884e-07 0 2.934e-07 0 \
    2.9345e-07 -0.1 2.984e-07 -0.1 2.9845e-07 0 3.0345e-07 0 \
    3.035e-07 -0.1 3.0845e-07 -0.1 3.085e-07 0 3.135e-07 0 \
    3.1355e-07 -0.1 3.185e-07 -0.1 3.1855e-07 0 3.2355e-07 0 \
    3.236e-07 -0.1 3.2855e-07 -0.1 3.286e-07 0 3.336e-07 0 \
    3.3365e-07 -0.1 3.386e-07 -0.1 3.3865e-07 0 3.4165e-07 0 \
    3.417e-07 -0.1 3.4565e-07 -0.1 3.457e-07 0 3.507e-07 0 \
    3.5075e-07 -0.19 3.557e-07 -0.19 3.5575e-07 0 3.6075e-07 0 \
    3.608e-07 -0.19 3.6575e-07 -0.19 3.658e-07 0 3.708e-07 0 \
    3.7085e-07 -0.19 3.758e-07 -0.19 3.7585e-07 0 3.8085e-07 0 \
    3.809e-07 -0.19 3.8585e-07 -0.19 3.859e-07 0 3.909e-07 0 \
    3.9095e-07 -0.19 3.959e-07 -0.19 3.9595e-07 0 3.9895e-07 0 \
    3.99e-07 -0.1 4.0295e-07 -0.1 4.03e-07 0 4.08e-07 0 \
    4.0805e-07 0.03 4.13e-07 0.03 4.1305e-07 0 4.1805e-07 0 \
    4.181e-07 0.03 4.2305e-07 0.03 4.231e-07 0 4.281e-07 0 \
    4.2815e-07 0.03 4.331e-07 0.03 4.3315e-07 0 4.3815e-07 0 \
    4.382e-07 0.03 4.4315e-07 0.03 4.432e-07 0 4.482e-07 0 \
    4.4825e-07 0.03 4.532e-07 0.03 4.5325e-07 0 4.5625e-07 0 \
    4.563e-07 -0.1 4.6025e-07 -0.1 4.603e-07 0 4.653e-07 0 \
    4.6535e-07 -0.21 4.703e-07 -0.21 4.7035e-07 0 4.7535e-07 0 \
    4.754e-07 -0.21 4.8035e-07 -0.21 4.804e-07 0 4.854e-07 0 \
    4.8545e-07 -0.21 4.904e-07 -0.21 4.9045e-07 0 4.9545e-07 0 \
    4.955e-07 -0.21 5.0045e-07 -0.21 5.005e-07 0 5.055e-07 0 \
    5.0555e-07 -0.21 5.105e-07 -0.21 5.1055e-07 0 5.1355e-07 0 \
    5.136e-07 -0.1 5.1755e-07 -0.1 5.176e-07 0 5.226e-07 0 ]

tran tran stop=5.226e-07 maxstep=1e-10 errpreset=conservative

save n_p X1:p X1.ws
