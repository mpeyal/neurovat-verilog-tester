// dc_loop.scs - GENERATED by validation/vteam/make_decks.py; do not edit.
// vteam-1 validation deck: VTEAM memristor (vteam) under 'dc_loop'
//   two triangle loops 0 -> +1 -> 0 -> -0.3 -> 0 V at 2.5e7 V/s from ON
// stimulus set vteam-1 (3103a410f6b1223a), t_stop 2.181e-07 s,
// 0 read plateau(s) at -0.1 V, maxstep 1e-10 s
//
// Model: S. Kvatinsky et al., "VTEAM: A General Model for Voltage-Controlled
// Memristors", IEEE TCAS-II 62(8), 2015; MemTorch 1.1.6 variant (see vteam.va).
//
// Run (writes dc_loop.raw/tran.tran.tran in PSF-ascii with Spectre 24.1):
//   spectre +escchars -format psfascii -raw dc_loop.raw +log dc_loop.log dc_loop.scs
// then import with validation/vteam/scrub.py.

simulator lang=spectre
global 0

ahdl_include "../../../verilog/vteam.va"

simOpts options reltol=1e-05 vabstol=1e-9 iabstol=1e-15 gmin=1e-15
saveOpts options save=selected

X1 (n_p 0) vteam

// V(p,n): PWL with exactly the twin's points
vin (n_p 0) vsource type=pwl wave=[ 0 0 1e-10 0 4.01e-08 1 8.01e-08 0 \
    9.21e-08 -0.3 1.041e-07 0 1.441e-07 1 1.841e-07 0 \
    1.961e-07 -0.3 2.081e-07 0 2.181e-07 0 ]

tran tran stop=2.181e-07 maxstep=1e-10 errpreset=conservative

save n_p X1:p X1.ws
