// saturate_reverse.scs - GENERATED by validation/vteam/make_decks.py; do not edit.
// vteam-1 validation deck: VTEAM memristor (vteam) under 'saturate_reverse'
//   from ON: +1 V / 150 ns into the x = d bound (reached at ~123 ns), read, then 10 x -0.22 V / 10 ns, each read (window: no wind-up)
// stimulus set vteam-1 (3103a410f6b1223a), t_stop 3.681e-07 s,
// 11 read plateau(s) at -0.1 V, maxstep 1e-10 s
//
// Model: S. Kvatinsky et al., "VTEAM: A General Model for Voltage-Controlled
// Memristors", IEEE TCAS-II 62(8), 2015; MemTorch 1.1.6 variant (see vteam.va).
//
// Run (writes saturate_reverse.raw/tran.tran.tran in PSF-ascii with Spectre 24.1):
//   spectre +escchars -format psfascii -raw saturate_reverse.raw +log saturate_reverse.log saturate_reverse.scs
// then import with validation/vteam/scrub.py.

simulator lang=spectre
global 0

ahdl_include "../../../verilog/vteam.va"

simOpts options reltol=1e-05 vabstol=1e-9 iabstol=1e-15 gmin=1e-15
saveOpts options save=selected

X1 (n_p 0) vteam

// V(p,n): PWL with exactly the twin's points
vin (n_p 0) vsource type=pwl wave=[ 0 0 1e-09 0 1.05e-09 1 1.51e-07 1 \
    1.5105e-07 0 1.5405e-07 0 1.541e-07 -0.1 1.5805e-07 -0.1 \
    1.581e-07 0 1.631e-07 0 1.6315e-07 -0.22 1.731e-07 -0.22 \
    1.7315e-07 0 1.7615e-07 0 1.762e-07 -0.1 1.8015e-07 -0.1 \
    1.802e-07 0 1.831e-07 0 1.8315e-07 -0.22 1.931e-07 -0.22 \
    1.9315e-07 0 1.9615e-07 0 1.962e-07 -0.1 2.0015e-07 -0.1 \
    2.002e-07 0 2.031e-07 0 2.0315e-07 -0.22 2.131e-07 -0.22 \
    2.1315e-07 0 2.1615e-07 0 2.162e-07 -0.1 2.2015e-07 -0.1 \
    2.202e-07 0 2.231e-07 0 2.2315e-07 -0.22 2.331e-07 -0.22 \
    2.3315e-07 0 2.3615e-07 0 2.362e-07 -0.1 2.4015e-07 -0.1 \
    2.402e-07 0 2.431e-07 0 2.4315e-07 -0.22 2.531e-07 -0.22 \
    2.5315e-07 0 2.5615e-07 0 2.562e-07 -0.1 2.6015e-07 -0.1 \
    2.602e-07 0 2.631e-07 0 2.6315e-07 -0.22 2.731e-07 -0.22 \
    2.7315e-07 0 2.7615e-07 0 2.762e-07 -0.1 2.8015e-07 -0.1 \
    2.802e-07 0 2.831e-07 0 2.8315e-07 -0.22 2.931e-07 -0.22 \
    2.9315e-07 0 2.9615e-07 0 2.962e-07 -0.1 3.0015e-07 -0.1 \
    3.002e-07 0 3.031e-07 0 3.0315e-07 -0.22 3.131e-07 -0.22 \
    3.1315e-07 0 3.1615e-07 0 3.162e-07 -0.1 3.2015e-07 -0.1 \
    3.202e-07 0 3.231e-07 0 3.2315e-07 -0.22 3.331e-07 -0.22 \
    3.3315e-07 0 3.3615e-07 0 3.362e-07 -0.1 3.4015e-07 -0.1 \
    3.402e-07 0 3.431e-07 0 3.4315e-07 -0.22 3.531e-07 -0.22 \
    3.5315e-07 0 3.5615e-07 0 3.562e-07 -0.1 3.6015e-07 -0.1 \
    3.602e-07 0 3.631e-07 0 3.681e-07 0 ]

tran tran stop=3.681e-07 maxstep=1e-10 errpreset=conservative

save n_p X1:p X1.ws
