// sine_memtorch.scs - GENERATED by validation/vteam/make_decks.py; do not edit.
// vteam-1 validation deck: VTEAM memristor (vteam) under 'sine_memtorch'
//   MemTorch hysteresis default: 1 V, 50 MHz sine for 200 ns (PWL, 100 ps points) from ON; -1 V crosses d in ~5 ps
// stimulus set vteam-1 (387eca88c0b9d6f4), t_stop 2e-07 s,
// 0 read plateau(s) at -0.1 V, maxstep 1e-10 s
//
// Model: S. Kvatinsky et al., "VTEAM: A General Model for Voltage-Controlled
// Memristors", IEEE TCAS-II 62(8), 2015; MemTorch 1.1.6 variant (see vteam.va).
//
// Run (writes sine_memtorch.raw/tran.tran.tran in PSF-ascii with Spectre 24.1):
//   spectre +escchars -format psfascii -raw sine_memtorch.raw +log sine_memtorch.log sine_memtorch.scs
// then import with validation/vteam/scrub.py.

simulator lang=spectre
global 0

ahdl_include "../../../verilog/vteam.va"

simOpts options reltol=1e-05 vabstol=1e-9 iabstol=1e-15 gmin=1e-15
saveOpts options save=selected

X1 (n_p 0) vteam

// V(p,n): PWL with exactly the twin's points
vin (n_p 0) vsource type=pwl wave=[ 0 0 1e-10 0.0314107591 2e-10 0.0627905195 3e-10 0.0941083133 \
    4e-10 0.125333234 5e-10 0.156434465 6e-10 0.187381315 7e-10 0.218143241 \
    8e-10 0.248689887 9e-10 0.278991106 1e-09 0.309016994 1.1e-09 0.33873792 \
    1.2e-09 0.368124553 1.3e-09 0.397147891 1.4e-09 0.425779292 1.5e-09 0.4539905 \
    1.6e-09 0.481753674 1.7e-09 0.509041416 1.8e-09 0.535826795 1.9e-09 0.562083378 \
    2e-09 0.587785252 2.1e-09 0.612907054 2.2e-09 0.63742399 2.3e-09 0.661311865 \
    2.4e-09 0.684547106 2.5e-09 0.707106781 2.6e-09 0.728968627 2.7e-09 0.75011107 \
    2.8e-09 0.770513243 2.9e-09 0.790155012 3e-09 0.809016994 3.1e-09 0.827080574 \
    3.2e-09 0.844327926 3.3e-09 0.860742027 3.4e-09 0.87630668 3.5e-09 0.891006524 \
    3.6e-09 0.904827052 3.7e-09 0.917754626 3.8e-09 0.929776486 3.9e-09 0.940880769 \
    4e-09 0.951056516 4.1e-09 0.960293686 4.2e-09 0.968583161 4.3e-09 0.975916762 \
    4.4e-09 0.982287251 4.5e-09 0.987688341 4.6e-09 0.992114701 4.7e-09 0.995561965 \
    4.8e-09 0.998026728 4.9e-09 0.99950656 5e-09 1 5.1e-09 0.99950656 \
    5.2e-09 0.998026728 5.3e-09 0.995561965 5.4e-09 0.992114701 5.5e-09 0.987688341 \
    5.6e-09 0.982287251 5.7e-09 0.975916762 5.8e-09 0.968583161 5.9e-09 0.960293686 \
    6e-09 0.951056516 6.1e-09 0.940880769 6.2e-09 0.929776486 6.3e-09 0.917754626 \
    6.4e-09 0.904827052 6.5e-09 0.891006524 6.6e-09 0.87630668 6.7e-09 0.860742027 \
    6.8e-09 0.844327926 6.9e-09 0.827080574 7e-09 0.809016994 7.1e-09 0.790155012 \
    7.2e-09 0.770513243 7.3e-09 0.75011107 7.4e-09 0.728968627 7.5e-09 0.707106781 \
    7.6e-09 0.684547106 7.7e-09 0.661311865 7.8e-09 0.63742399 7.9e-09 0.612907054 \
    8e-09 0.587785252 8.1e-09 0.562083378 8.2e-09 0.535826795 8.3e-09 0.509041416 \
    8.4e-09 0.481753674 8.5e-09 0.4539905 8.6e-09 0.425779292 8.7e-09 0.397147891 \
    8.8e-09 0.368124553 8.9e-09 0.33873792 9e-09 0.309016994 9.1e-09 0.278991106 \
    9.2e-09 0.248689887 9.3e-09 0.218143241 9.4e-09 0.187381315 9.5e-09 0.156434465 \
    9.6e-09 0.125333234 9.7e-09 0.0941083133 9.8e-09 0.0627905195 9.9e-09 0.0314107591 \
    1e-08 0 1.01e-08 -0.0314107591 1.02e-08 -0.0627905195 1.03e-08 -0.0941083133 \
    1.04e-08 -0.125333234 1.05e-08 -0.156434465 1.06e-08 -0.187381315 1.07e-08 -0.218143241 \
    1.08e-08 -0.248689887 1.09e-08 -0.278991106 1.1e-08 -0.309016994 1.11e-08 -0.33873792 \
    1.12e-08 -0.368124553 1.13e-08 -0.397147891 1.14e-08 -0.425779292 1.15e-08 -0.4539905 \
    1.16e-08 -0.481753674 1.17e-08 -0.509041416 1.18e-08 -0.535826795 1.19e-08 -0.562083378 \
    1.2e-08 -0.587785252 1.21e-08 -0.612907054 1.22e-08 -0.63742399 1.23e-08 -0.661311865 \
    1.24e-08 -0.684547106 1.25e-08 -0.707106781 1.26e-08 -0.728968627 1.27e-08 -0.75011107 \
    1.28e-08 -0.770513243 1.29e-08 -0.790155012 1.3e-08 -0.809016994 1.31e-08 -0.827080574 \
    1.32e-08 -0.844327926 1.33e-08 -0.860742027 1.34e-08 -0.87630668 1.35e-08 -0.891006524 \
    1.36e-08 -0.904827052 1.37e-08 -0.917754626 1.38e-08 -0.929776486 1.39e-08 -0.940880769 \
    1.4e-08 -0.951056516 1.41e-08 -0.960293686 1.42e-08 -0.968583161 1.43e-08 -0.975916762 \
    1.44e-08 -0.982287251 1.45e-08 -0.987688341 1.46e-08 -0.992114701 1.47e-08 -0.995561965 \
    1.48e-08 -0.998026728 1.49e-08 -0.99950656 1.5e-08 -1 1.51e-08 -0.99950656 \
    1.52e-08 -0.998026728 1.53e-08 -0.995561965 1.54e-08 -0.992114701 1.55e-08 -0.987688341 \
    1.56e-08 -0.982287251 1.57e-08 -0.975916762 1.58e-08 -0.968583161 1.59e-08 -0.960293686 \
    1.6e-08 -0.951056516 1.61e-08 -0.940880769 1.62e-08 -0.929776486 1.63e-08 -0.917754626 \
    1.64e-08 -0.904827052 1.65e-08 -0.891006524 1.66e-08 -0.87630668 1.67e-08 -0.860742027 \
    1.68e-08 -0.844327926 1.69e-08 -0.827080574 1.7e-08 -0.809016994 1.71e-08 -0.790155012 \
    1.72e-08 -0.770513243 1.73e-08 -0.75011107 1.74e-08 -0.728968627 1.75e-08 -0.707106781 \
    1.76e-08 -0.684547106 1.77e-08 -0.661311865 1.78e-08 -0.63742399 1.79e-08 -0.612907054 \
    1.8e-08 -0.587785252 1.81e-08 -0.562083378 1.82e-08 -0.535826795 1.83e-08 -0.509041416 \
    1.84e-08 -0.481753674 1.85e-08 -0.4539905 1.86e-08 -0.425779292 1.87e-08 -0.397147891 \
    1.88e-08 -0.368124553 1.89e-08 -0.33873792 1.9e-08 -0.309016994 1.91e-08 -0.278991106 \
    1.92e-08 -0.248689887 1.93e-08 -0.218143241 1.94e-08 -0.187381315 1.95e-08 -0.156434465 \
    1.96e-08 -0.125333234 1.97e-08 -0.0941083133 1.98e-08 -0.0627905195 1.99e-08 -0.0314107591 \
    2e-08 0 2.01e-08 0.0314107591 2.02e-08 0.0627905195 2.03e-08 0.0941083133 \
    2.04e-08 0.125333234 2.05e-08 0.156434465 2.06e-08 0.187381315 2.07e-08 0.218143241 \
    2.08e-08 0.248689887 2.09e-08 0.278991106 2.1e-08 0.309016994 2.11e-08 0.33873792 \
    2.12e-08 0.368124553 2.13e-08 0.397147891 2.14e-08 0.425779292 2.15e-08 0.4539905 \
    2.16e-08 0.481753674 2.17e-08 0.509041416 2.18e-08 0.535826795 2.19e-08 0.562083378 \
    2.2e-08 0.587785252 2.21e-08 0.612907054 2.22e-08 0.63742399 2.23e-08 0.661311865 \
    2.24e-08 0.684547106 2.25e-08 0.707106781 2.26e-08 0.728968627 2.27e-08 0.75011107 \
    2.28e-08 0.770513243 2.29e-08 0.790155012 2.3e-08 0.809016994 2.31e-08 0.827080574 \
    2.32e-08 0.844327926 2.33e-08 0.860742027 2.34e-08 0.87630668 2.35e-08 0.891006524 \
    2.36e-08 0.904827052 2.37e-08 0.917754626 2.38e-08 0.929776486 2.39e-08 0.940880769 \
    2.4e-08 0.951056516 2.41e-08 0.960293686 2.42e-08 0.968583161 2.43e-08 0.975916762 \
    2.44e-08 0.982287251 2.45e-08 0.987688341 2.46e-08 0.992114701 2.47e-08 0.995561965 \
    2.48e-08 0.998026728 2.49e-08 0.99950656 2.5e-08 1 2.51e-08 0.99950656 \
    2.52e-08 0.998026728 2.53e-08 0.995561965 2.54e-08 0.992114701 2.55e-08 0.987688341 \
    2.56e-08 0.982287251 2.57e-08 0.975916762 2.58e-08 0.968583161 2.59e-08 0.960293686 \
    2.6e-08 0.951056516 2.61e-08 0.940880769 2.62e-08 0.929776486 2.63e-08 0.917754626 \
    2.64e-08 0.904827052 2.65e-08 0.891006524 2.66e-08 0.87630668 2.67e-08 0.860742027 \
    2.68e-08 0.844327926 2.69e-08 0.827080574 2.7e-08 0.809016994 2.71e-08 0.790155012 \
    2.72e-08 0.770513243 2.73e-08 0.75011107 2.74e-08 0.728968627 2.75e-08 0.707106781 \
    2.76e-08 0.684547106 2.77e-08 0.661311865 2.78e-08 0.63742399 2.79e-08 0.612907054 \
    2.8e-08 0.587785252 2.81e-08 0.562083378 2.82e-08 0.535826795 2.83e-08 0.509041416 \
    2.84e-08 0.481753674 2.85e-08 0.4539905 2.86e-08 0.425779292 2.87e-08 0.397147891 \
    2.88e-08 0.368124553 2.89e-08 0.33873792 2.9e-08 0.309016994 2.91e-08 0.278991106 \
    2.92e-08 0.248689887 2.93e-08 0.218143241 2.94e-08 0.187381315 2.95e-08 0.156434465 \
    2.96e-08 0.125333234 2.97e-08 0.0941083133 2.98e-08 0.0627905195 2.99e-08 0.0314107591 \
    3e-08 0 3.01e-08 -0.0314107591 3.02e-08 -0.0627905195 3.03e-08 -0.0941083133 \
    3.04e-08 -0.125333234 3.05e-08 -0.156434465 3.06e-08 -0.187381315 3.07e-08 -0.218143241 \
    3.08e-08 -0.248689887 3.09e-08 -0.278991106 3.1e-08 -0.309016994 3.11e-08 -0.33873792 \
    3.12e-08 -0.368124553 3.13e-08 -0.397147891 3.14e-08 -0.425779292 3.15e-08 -0.4539905 \
    3.16e-08 -0.481753674 3.17e-08 -0.509041416 3.18e-08 -0.535826795 3.19e-08 -0.562083378 \
    3.2e-08 -0.587785252 3.21e-08 -0.612907054 3.22e-08 -0.63742399 3.23e-08 -0.661311865 \
    3.24e-08 -0.684547106 3.25e-08 -0.707106781 3.26e-08 -0.728968627 3.27e-08 -0.75011107 \
    3.28e-08 -0.770513243 3.29e-08 -0.790155012 3.3e-08 -0.809016994 3.31e-08 -0.827080574 \
    3.32e-08 -0.844327926 3.33e-08 -0.860742027 3.34e-08 -0.87630668 3.35e-08 -0.891006524 \
    3.36e-08 -0.904827052 3.37e-08 -0.917754626 3.38e-08 -0.929776486 3.39e-08 -0.940880769 \
    3.4e-08 -0.951056516 3.41e-08 -0.960293686 3.42e-08 -0.968583161 3.43e-08 -0.975916762 \
    3.44e-08 -0.982287251 3.45e-08 -0.987688341 3.46e-08 -0.992114701 3.47e-08 -0.995561965 \
    3.48e-08 -0.998026728 3.49e-08 -0.99950656 3.5e-08 -1 3.51e-08 -0.99950656 \
    3.52e-08 -0.998026728 3.53e-08 -0.995561965 3.54e-08 -0.992114701 3.55e-08 -0.987688341 \
    3.56e-08 -0.982287251 3.57e-08 -0.975916762 3.58e-08 -0.968583161 3.59e-08 -0.960293686 \
    3.6e-08 -0.951056516 3.61e-08 -0.940880769 3.62e-08 -0.929776486 3.63e-08 -0.917754626 \
    3.64e-08 -0.904827052 3.65e-08 -0.891006524 3.66e-08 -0.87630668 3.67e-08 -0.860742027 \
    3.68e-08 -0.844327926 3.69e-08 -0.827080574 3.7e-08 -0.809016994 3.71e-08 -0.790155012 \
    3.72e-08 -0.770513243 3.73e-08 -0.75011107 3.74e-08 -0.728968627 3.75e-08 -0.707106781 \
    3.76e-08 -0.684547106 3.77e-08 -0.661311865 3.78e-08 -0.63742399 3.79e-08 -0.612907054 \
    3.8e-08 -0.587785252 3.81e-08 -0.562083378 3.82e-08 -0.535826795 3.83e-08 -0.509041416 \
    3.84e-08 -0.481753674 3.85e-08 -0.4539905 3.86e-08 -0.425779292 3.87e-08 -0.397147891 \
    3.88e-08 -0.368124553 3.89e-08 -0.33873792 3.9e-08 -0.309016994 3.91e-08 -0.278991106 \
    3.92e-08 -0.248689887 3.93e-08 -0.218143241 3.94e-08 -0.187381315 3.95e-08 -0.156434465 \
    3.96e-08 -0.125333234 3.97e-08 -0.0941083133 3.98e-08 -0.0627905195 3.99e-08 -0.0314107591 \
    4e-08 0 4.01e-08 0.0314107591 4.02e-08 0.0627905195 4.03e-08 0.0941083133 \
    4.04e-08 0.125333234 4.05e-08 0.156434465 4.06e-08 0.187381315 4.07e-08 0.218143241 \
    4.08e-08 0.248689887 4.09e-08 0.278991106 4.1e-08 0.309016994 4.11e-08 0.33873792 \
    4.12e-08 0.368124553 4.13e-08 0.397147891 4.14e-08 0.425779292 4.15e-08 0.4539905 \
    4.16e-08 0.481753674 4.17e-08 0.509041416 4.18e-08 0.535826795 4.19e-08 0.562083378 \
    4.2e-08 0.587785252 4.21e-08 0.612907054 4.22e-08 0.63742399 4.23e-08 0.661311865 \
    4.24e-08 0.684547106 4.25e-08 0.707106781 4.26e-08 0.728968627 4.27e-08 0.75011107 \
    4.28e-08 0.770513243 4.29e-08 0.790155012 4.3e-08 0.809016994 4.31e-08 0.827080574 \
    4.32e-08 0.844327926 4.33e-08 0.860742027 4.34e-08 0.87630668 4.35e-08 0.891006524 \
    4.36e-08 0.904827052 4.37e-08 0.917754626 4.38e-08 0.929776486 4.39e-08 0.940880769 \
    4.4e-08 0.951056516 4.41e-08 0.960293686 4.42e-08 0.968583161 4.43e-08 0.975916762 \
    4.44e-08 0.982287251 4.45e-08 0.987688341 4.46e-08 0.992114701 4.47e-08 0.995561965 \
    4.48e-08 0.998026728 4.49e-08 0.99950656 4.5e-08 1 4.51e-08 0.99950656 \
    4.52e-08 0.998026728 4.53e-08 0.995561965 4.54e-08 0.992114701 4.55e-08 0.987688341 \
    4.56e-08 0.982287251 4.57e-08 0.975916762 4.58e-08 0.968583161 4.59e-08 0.960293686 \
    4.6e-08 0.951056516 4.61e-08 0.940880769 4.62e-08 0.929776486 4.63e-08 0.917754626 \
    4.64e-08 0.904827052 4.65e-08 0.891006524 4.66e-08 0.87630668 4.67e-08 0.860742027 \
    4.68e-08 0.844327926 4.69e-08 0.827080574 4.7e-08 0.809016994 4.71e-08 0.790155012 \
    4.72e-08 0.770513243 4.73e-08 0.75011107 4.74e-08 0.728968627 4.75e-08 0.707106781 \
    4.76e-08 0.684547106 4.77e-08 0.661311865 4.78e-08 0.63742399 4.79e-08 0.612907054 \
    4.8e-08 0.587785252 4.81e-08 0.562083378 4.82e-08 0.535826795 4.83e-08 0.509041416 \
    4.84e-08 0.481753674 4.85e-08 0.4539905 4.86e-08 0.425779292 4.87e-08 0.397147891 \
    4.88e-08 0.368124553 4.89e-08 0.33873792 4.9e-08 0.309016994 4.91e-08 0.278991106 \
    4.92e-08 0.248689887 4.93e-08 0.218143241 4.94e-08 0.187381315 4.95e-08 0.156434465 \
    4.96e-08 0.125333234 4.97e-08 0.0941083133 4.98e-08 0.0627905195 4.99e-08 0.0314107591 \
    5e-08 0 5.01e-08 -0.0314107591 5.02e-08 -0.0627905195 5.03e-08 -0.0941083133 \
    5.04e-08 -0.125333234 5.05e-08 -0.156434465 5.06e-08 -0.187381315 5.07e-08 -0.218143241 \
    5.08e-08 -0.248689887 5.09e-08 -0.278991106 5.1e-08 -0.309016994 5.11e-08 -0.33873792 \
    5.12e-08 -0.368124553 5.13e-08 -0.397147891 5.14e-08 -0.425779292 5.15e-08 -0.4539905 \
    5.16e-08 -0.481753674 5.17e-08 -0.509041416 5.18e-08 -0.535826795 5.19e-08 -0.562083378 \
    5.2e-08 -0.587785252 5.21e-08 -0.612907054 5.22e-08 -0.63742399 5.23e-08 -0.661311865 \
    5.24e-08 -0.684547106 5.25e-08 -0.707106781 5.26e-08 -0.728968627 5.27e-08 -0.75011107 \
    5.28e-08 -0.770513243 5.29e-08 -0.790155012 5.3e-08 -0.809016994 5.31e-08 -0.827080574 \
    5.32e-08 -0.844327926 5.33e-08 -0.860742027 5.34e-08 -0.87630668 5.35e-08 -0.891006524 \
    5.36e-08 -0.904827052 5.37e-08 -0.917754626 5.38e-08 -0.929776486 5.39e-08 -0.940880769 \
    5.4e-08 -0.951056516 5.41e-08 -0.960293686 5.42e-08 -0.968583161 5.43e-08 -0.975916762 \
    5.44e-08 -0.982287251 5.45e-08 -0.987688341 5.46e-08 -0.992114701 5.47e-08 -0.995561965 \
    5.48e-08 -0.998026728 5.49e-08 -0.99950656 5.5e-08 -1 5.51e-08 -0.99950656 \
    5.52e-08 -0.998026728 5.53e-08 -0.995561965 5.54e-08 -0.992114701 5.55e-08 -0.987688341 \
    5.56e-08 -0.982287251 5.57e-08 -0.975916762 5.58e-08 -0.968583161 5.59e-08 -0.960293686 \
    5.6e-08 -0.951056516 5.61e-08 -0.940880769 5.62e-08 -0.929776486 5.63e-08 -0.917754626 \
    5.64e-08 -0.904827052 5.65e-08 -0.891006524 5.66e-08 -0.87630668 5.67e-08 -0.860742027 \
    5.68e-08 -0.844327926 5.69e-08 -0.827080574 5.7e-08 -0.809016994 5.71e-08 -0.790155012 \
    5.72e-08 -0.770513243 5.73e-08 -0.75011107 5.74e-08 -0.728968627 5.75e-08 -0.707106781 \
    5.76e-08 -0.684547106 5.77e-08 -0.661311865 5.78e-08 -0.63742399 5.79e-08 -0.612907054 \
    5.8e-08 -0.587785252 5.81e-08 -0.562083378 5.82e-08 -0.535826795 5.83e-08 -0.509041416 \
    5.84e-08 -0.481753674 5.85e-08 -0.4539905 5.86e-08 -0.425779292 5.87e-08 -0.397147891 \
    5.88e-08 -0.368124553 5.89e-08 -0.33873792 5.9e-08 -0.309016994 5.91e-08 -0.278991106 \
    5.92e-08 -0.248689887 5.93e-08 -0.218143241 5.94e-08 -0.187381315 5.95e-08 -0.156434465 \
    5.96e-08 -0.125333234 5.97e-08 -0.0941083133 5.98e-08 -0.0627905195 5.99e-08 -0.0314107591 \
    6e-08 0 6.01e-08 0.0314107591 6.02e-08 0.0627905195 6.03e-08 0.0941083133 \
    6.04e-08 0.125333234 6.05e-08 0.156434465 6.06e-08 0.187381315 6.07e-08 0.218143241 \
    6.08e-08 0.248689887 6.09e-08 0.278991106 6.1e-08 0.309016994 6.11e-08 0.33873792 \
    6.12e-08 0.368124553 6.13e-08 0.397147891 6.14e-08 0.425779292 6.15e-08 0.4539905 \
    6.16e-08 0.481753674 6.17e-08 0.509041416 6.18e-08 0.535826795 6.19e-08 0.562083378 \
    6.2e-08 0.587785252 6.21e-08 0.612907054 6.22e-08 0.63742399 6.23e-08 0.661311865 \
    6.24e-08 0.684547106 6.25e-08 0.707106781 6.26e-08 0.728968627 6.27e-08 0.75011107 \
    6.28e-08 0.770513243 6.29e-08 0.790155012 6.3e-08 0.809016994 6.31e-08 0.827080574 \
    6.32e-08 0.844327926 6.33e-08 0.860742027 6.34e-08 0.87630668 6.35e-08 0.891006524 \
    6.36e-08 0.904827052 6.37e-08 0.917754626 6.38e-08 0.929776486 6.39e-08 0.940880769 \
    6.4e-08 0.951056516 6.41e-08 0.960293686 6.42e-08 0.968583161 6.43e-08 0.975916762 \
    6.44e-08 0.982287251 6.45e-08 0.987688341 6.46e-08 0.992114701 6.47e-08 0.995561965 \
    6.48e-08 0.998026728 6.49e-08 0.99950656 6.5e-08 1 6.51e-08 0.99950656 \
    6.52e-08 0.998026728 6.53e-08 0.995561965 6.54e-08 0.992114701 6.55e-08 0.987688341 \
    6.56e-08 0.982287251 6.57e-08 0.975916762 6.58e-08 0.968583161 6.59e-08 0.960293686 \
    6.6e-08 0.951056516 6.61e-08 0.940880769 6.62e-08 0.929776486 6.63e-08 0.917754626 \
    6.64e-08 0.904827052 6.65e-08 0.891006524 6.66e-08 0.87630668 6.67e-08 0.860742027 \
    6.68e-08 0.844327926 6.69e-08 0.827080574 6.7e-08 0.809016994 6.71e-08 0.790155012 \
    6.72e-08 0.770513243 6.73e-08 0.75011107 6.74e-08 0.728968627 6.75e-08 0.707106781 \
    6.76e-08 0.684547106 6.77e-08 0.661311865 6.78e-08 0.63742399 6.79e-08 0.612907054 \
    6.8e-08 0.587785252 6.81e-08 0.562083378 6.82e-08 0.535826795 6.83e-08 0.509041416 \
    6.84e-08 0.481753674 6.85e-08 0.4539905 6.86e-08 0.425779292 6.87e-08 0.397147891 \
    6.88e-08 0.368124553 6.89e-08 0.33873792 6.9e-08 0.309016994 6.91e-08 0.278991106 \
    6.92e-08 0.248689887 6.93e-08 0.218143241 6.94e-08 0.187381315 6.95e-08 0.156434465 \
    6.96e-08 0.125333234 6.97e-08 0.0941083133 6.98e-08 0.0627905195 6.99e-08 0.0314107591 \
    7e-08 0 7.01e-08 -0.0314107591 7.02e-08 -0.0627905195 7.03e-08 -0.0941083133 \
    7.04e-08 -0.125333234 7.05e-08 -0.156434465 7.06e-08 -0.187381315 7.07e-08 -0.218143241 \
    7.08e-08 -0.248689887 7.09e-08 -0.278991106 7.1e-08 -0.309016994 7.11e-08 -0.33873792 \
    7.12e-08 -0.368124553 7.13e-08 -0.397147891 7.14e-08 -0.425779292 7.15e-08 -0.4539905 \
    7.16e-08 -0.481753674 7.17e-08 -0.509041416 7.18e-08 -0.535826795 7.19e-08 -0.562083378 \
    7.2e-08 -0.587785252 7.21e-08 -0.612907054 7.22e-08 -0.63742399 7.23e-08 -0.661311865 \
    7.24e-08 -0.684547106 7.25e-08 -0.707106781 7.26e-08 -0.728968627 7.27e-08 -0.75011107 \
    7.28e-08 -0.770513243 7.29e-08 -0.790155012 7.3e-08 -0.809016994 7.31e-08 -0.827080574 \
    7.32e-08 -0.844327926 7.33e-08 -0.860742027 7.34e-08 -0.87630668 7.35e-08 -0.891006524 \
    7.36e-08 -0.904827052 7.37e-08 -0.917754626 7.38e-08 -0.929776486 7.39e-08 -0.940880769 \
    7.4e-08 -0.951056516 7.41e-08 -0.960293686 7.42e-08 -0.968583161 7.43e-08 -0.975916762 \
    7.44e-08 -0.982287251 7.45e-08 -0.987688341 7.46e-08 -0.992114701 7.47e-08 -0.995561965 \
    7.48e-08 -0.998026728 7.49e-08 -0.99950656 7.5e-08 -1 7.51e-08 -0.99950656 \
    7.52e-08 -0.998026728 7.53e-08 -0.995561965 7.54e-08 -0.992114701 7.55e-08 -0.987688341 \
    7.56e-08 -0.982287251 7.57e-08 -0.975916762 7.58e-08 -0.968583161 7.59e-08 -0.960293686 \
    7.6e-08 -0.951056516 7.61e-08 -0.940880769 7.62e-08 -0.929776486 7.63e-08 -0.917754626 \
    7.64e-08 -0.904827052 7.65e-08 -0.891006524 7.66e-08 -0.87630668 7.67e-08 -0.860742027 \
    7.68e-08 -0.844327926 7.69e-08 -0.827080574 7.7e-08 -0.809016994 7.71e-08 -0.790155012 \
    7.72e-08 -0.770513243 7.73e-08 -0.75011107 7.74e-08 -0.728968627 7.75e-08 -0.707106781 \
    7.76e-08 -0.684547106 7.77e-08 -0.661311865 7.78e-08 -0.63742399 7.79e-08 -0.612907054 \
    7.8e-08 -0.587785252 7.81e-08 -0.562083378 7.82e-08 -0.535826795 7.83e-08 -0.509041416 \
    7.84e-08 -0.481753674 7.85e-08 -0.4539905 7.86e-08 -0.425779292 7.87e-08 -0.397147891 \
    7.88e-08 -0.368124553 7.89e-08 -0.33873792 7.9e-08 -0.309016994 7.91e-08 -0.278991106 \
    7.92e-08 -0.248689887 7.93e-08 -0.218143241 7.94e-08 -0.187381315 7.95e-08 -0.156434465 \
    7.96e-08 -0.125333234 7.97e-08 -0.0941083133 7.98e-08 -0.0627905195 7.99e-08 -0.0314107591 \
    8e-08 0 8.01e-08 0.0314107591 8.02e-08 0.0627905195 8.03e-08 0.0941083133 \
    8.04e-08 0.125333234 8.05e-08 0.156434465 8.06e-08 0.187381315 8.07e-08 0.218143241 \
    8.08e-08 0.248689887 8.09e-08 0.278991106 8.1e-08 0.309016994 8.11e-08 0.33873792 \
    8.12e-08 0.368124553 8.13e-08 0.397147891 8.14e-08 0.425779292 8.15e-08 0.4539905 \
    8.16e-08 0.481753674 8.17e-08 0.509041416 8.18e-08 0.535826795 8.19e-08 0.562083378 \
    8.2e-08 0.587785252 8.21e-08 0.612907054 8.22e-08 0.63742399 8.23e-08 0.661311865 \
    8.24e-08 0.684547106 8.25e-08 0.707106781 8.26e-08 0.728968627 8.27e-08 0.75011107 \
    8.28e-08 0.770513243 8.29e-08 0.790155012 8.3e-08 0.809016994 8.31e-08 0.827080574 \
    8.32e-08 0.844327926 8.33e-08 0.860742027 8.34e-08 0.87630668 8.35e-08 0.891006524 \
    8.36e-08 0.904827052 8.37e-08 0.917754626 8.38e-08 0.929776486 8.39e-08 0.940880769 \
    8.4e-08 0.951056516 8.41e-08 0.960293686 8.42e-08 0.968583161 8.43e-08 0.975916762 \
    8.44e-08 0.982287251 8.45e-08 0.987688341 8.46e-08 0.992114701 8.47e-08 0.995561965 \
    8.48e-08 0.998026728 8.49e-08 0.99950656 8.5e-08 1 8.51e-08 0.99950656 \
    8.52e-08 0.998026728 8.53e-08 0.995561965 8.54e-08 0.992114701 8.55e-08 0.987688341 \
    8.56e-08 0.982287251 8.57e-08 0.975916762 8.58e-08 0.968583161 8.59e-08 0.960293686 \
    8.6e-08 0.951056516 8.61e-08 0.940880769 8.62e-08 0.929776486 8.63e-08 0.917754626 \
    8.64e-08 0.904827052 8.65e-08 0.891006524 8.66e-08 0.87630668 8.67e-08 0.860742027 \
    8.68e-08 0.844327926 8.69e-08 0.827080574 8.7e-08 0.809016994 8.71e-08 0.790155012 \
    8.72e-08 0.770513243 8.73e-08 0.75011107 8.74e-08 0.728968627 8.75e-08 0.707106781 \
    8.76e-08 0.684547106 8.77e-08 0.661311865 8.78e-08 0.63742399 8.79e-08 0.612907054 \
    8.8e-08 0.587785252 8.81e-08 0.562083378 8.82e-08 0.535826795 8.83e-08 0.509041416 \
    8.84e-08 0.481753674 8.85e-08 0.4539905 8.86e-08 0.425779292 8.87e-08 0.397147891 \
    8.88e-08 0.368124553 8.89e-08 0.33873792 8.9e-08 0.309016994 8.91e-08 0.278991106 \
    8.92e-08 0.248689887 8.93e-08 0.218143241 8.94e-08 0.187381315 8.95e-08 0.156434465 \
    8.96e-08 0.125333234 8.97e-08 0.0941083133 8.98e-08 0.0627905195 8.99e-08 0.0314107591 \
    9e-08 0 9.01e-08 -0.0314107591 9.02e-08 -0.0627905195 9.03e-08 -0.0941083133 \
    9.04e-08 -0.125333234 9.05e-08 -0.156434465 9.06e-08 -0.187381315 9.07e-08 -0.218143241 \
    9.08e-08 -0.248689887 9.09e-08 -0.278991106 9.1e-08 -0.309016994 9.11e-08 -0.33873792 \
    9.12e-08 -0.368124553 9.13e-08 -0.397147891 9.14e-08 -0.425779292 9.15e-08 -0.4539905 \
    9.16e-08 -0.481753674 9.17e-08 -0.509041416 9.18e-08 -0.535826795 9.19e-08 -0.562083378 \
    9.2e-08 -0.587785252 9.21e-08 -0.612907054 9.22e-08 -0.63742399 9.23e-08 -0.661311865 \
    9.24e-08 -0.684547106 9.25e-08 -0.707106781 9.26e-08 -0.728968627 9.27e-08 -0.75011107 \
    9.28e-08 -0.770513243 9.29e-08 -0.790155012 9.3e-08 -0.809016994 9.31e-08 -0.827080574 \
    9.32e-08 -0.844327926 9.33e-08 -0.860742027 9.34e-08 -0.87630668 9.35e-08 -0.891006524 \
    9.36e-08 -0.904827052 9.37e-08 -0.917754626 9.38e-08 -0.929776486 9.39e-08 -0.940880769 \
    9.4e-08 -0.951056516 9.41e-08 -0.960293686 9.42e-08 -0.968583161 9.43e-08 -0.975916762 \
    9.44e-08 -0.982287251 9.45e-08 -0.987688341 9.46e-08 -0.992114701 9.47e-08 -0.995561965 \
    9.48e-08 -0.998026728 9.49e-08 -0.99950656 9.5e-08 -1 9.51e-08 -0.99950656 \
    9.52e-08 -0.998026728 9.53e-08 -0.995561965 9.54e-08 -0.992114701 9.55e-08 -0.987688341 \
    9.56e-08 -0.982287251 9.57e-08 -0.975916762 9.58e-08 -0.968583161 9.59e-08 -0.960293686 \
    9.6e-08 -0.951056516 9.61e-08 -0.940880769 9.62e-08 -0.929776486 9.63e-08 -0.917754626 \
    9.64e-08 -0.904827052 9.65e-08 -0.891006524 9.66e-08 -0.87630668 9.67e-08 -0.860742027 \
    9.68e-08 -0.844327926 9.69e-08 -0.827080574 9.7e-08 -0.809016994 9.71e-08 -0.790155012 \
    9.72e-08 -0.770513243 9.73e-08 -0.75011107 9.74e-08 -0.728968627 9.75e-08 -0.707106781 \
    9.76e-08 -0.684547106 9.77e-08 -0.661311865 9.78e-08 -0.63742399 9.79e-08 -0.612907054 \
    9.8e-08 -0.587785252 9.81e-08 -0.562083378 9.82e-08 -0.535826795 9.83e-08 -0.509041416 \
    9.84e-08 -0.481753674 9.85e-08 -0.4539905 9.86e-08 -0.425779292 9.87e-08 -0.397147891 \
    9.88e-08 -0.368124553 9.89e-08 -0.33873792 9.9e-08 -0.309016994 9.91e-08 -0.278991106 \
    9.92e-08 -0.248689887 9.93e-08 -0.218143241 9.94e-08 -0.187381315 9.95e-08 -0.156434465 \
    9.96e-08 -0.125333234 9.97e-08 -0.0941083133 9.98e-08 -0.0627905195 9.99e-08 -0.0314107591 \
    1e-07 0 1.001e-07 0.0314107591 1.002e-07 0.0627905195 1.003e-07 0.0941083133 \
    1.004e-07 0.125333234 1.005e-07 0.156434465 1.006e-07 0.187381315 1.007e-07 0.218143241 \
    1.008e-07 0.248689887 1.009e-07 0.278991106 1.01e-07 0.309016994 1.011e-07 0.33873792 \
    1.012e-07 0.368124553 1.013e-07 0.397147891 1.014e-07 0.425779292 1.015e-07 0.4539905 \
    1.016e-07 0.481753674 1.017e-07 0.509041416 1.018e-07 0.535826795 1.019e-07 0.562083378 \
    1.02e-07 0.587785252 1.021e-07 0.612907054 1.022e-07 0.63742399 1.023e-07 0.661311865 \
    1.024e-07 0.684547106 1.025e-07 0.707106781 1.026e-07 0.728968627 1.027e-07 0.75011107 \
    1.028e-07 0.770513243 1.029e-07 0.790155012 1.03e-07 0.809016994 1.031e-07 0.827080574 \
    1.032e-07 0.844327926 1.033e-07 0.860742027 1.034e-07 0.87630668 1.035e-07 0.891006524 \
    1.036e-07 0.904827052 1.037e-07 0.917754626 1.038e-07 0.929776486 1.039e-07 0.940880769 \
    1.04e-07 0.951056516 1.041e-07 0.960293686 1.042e-07 0.968583161 1.043e-07 0.975916762 \
    1.044e-07 0.982287251 1.045e-07 0.987688341 1.046e-07 0.992114701 1.047e-07 0.995561965 \
    1.048e-07 0.998026728 1.049e-07 0.99950656 1.05e-07 1 1.051e-07 0.99950656 \
    1.052e-07 0.998026728 1.053e-07 0.995561965 1.054e-07 0.992114701 1.055e-07 0.987688341 \
    1.056e-07 0.982287251 1.057e-07 0.975916762 1.058e-07 0.968583161 1.059e-07 0.960293686 \
    1.06e-07 0.951056516 1.061e-07 0.940880769 1.062e-07 0.929776486 1.063e-07 0.917754626 \
    1.064e-07 0.904827052 1.065e-07 0.891006524 1.066e-07 0.87630668 1.067e-07 0.860742027 \
    1.068e-07 0.844327926 1.069e-07 0.827080574 1.07e-07 0.809016994 1.071e-07 0.790155012 \
    1.072e-07 0.770513243 1.073e-07 0.75011107 1.074e-07 0.728968627 1.075e-07 0.707106781 \
    1.076e-07 0.684547106 1.077e-07 0.661311865 1.078e-07 0.63742399 1.079e-07 0.612907054 \
    1.08e-07 0.587785252 1.081e-07 0.562083378 1.082e-07 0.535826795 1.083e-07 0.509041416 \
    1.084e-07 0.481753674 1.085e-07 0.4539905 1.086e-07 0.425779292 1.087e-07 0.397147891 \
    1.088e-07 0.368124553 1.089e-07 0.33873792 1.09e-07 0.309016994 1.091e-07 0.278991106 \
    1.092e-07 0.248689887 1.093e-07 0.218143241 1.094e-07 0.187381315 1.095e-07 0.156434465 \
    1.096e-07 0.125333234 1.097e-07 0.0941083133 1.098e-07 0.0627905195 1.099e-07 0.0314107591 \
    1.1e-07 0 1.101e-07 -0.0314107591 1.102e-07 -0.0627905195 1.103e-07 -0.0941083133 \
    1.104e-07 -0.125333234 1.105e-07 -0.156434465 1.106e-07 -0.187381315 1.107e-07 -0.218143241 \
    1.108e-07 -0.248689887 1.109e-07 -0.278991106 1.11e-07 -0.309016994 1.111e-07 -0.33873792 \
    1.112e-07 -0.368124553 1.113e-07 -0.397147891 1.114e-07 -0.425779292 1.115e-07 -0.4539905 \
    1.116e-07 -0.481753674 1.117e-07 -0.509041416 1.118e-07 -0.535826795 1.119e-07 -0.562083378 \
    1.12e-07 -0.587785252 1.121e-07 -0.612907054 1.122e-07 -0.63742399 1.123e-07 -0.661311865 \
    1.124e-07 -0.684547106 1.125e-07 -0.707106781 1.126e-07 -0.728968627 1.127e-07 -0.75011107 \
    1.128e-07 -0.770513243 1.129e-07 -0.790155012 1.13e-07 -0.809016994 1.131e-07 -0.827080574 \
    1.132e-07 -0.844327926 1.133e-07 -0.860742027 1.134e-07 -0.87630668 1.135e-07 -0.891006524 \
    1.136e-07 -0.904827052 1.137e-07 -0.917754626 1.138e-07 -0.929776486 1.139e-07 -0.940880769 \
    1.14e-07 -0.951056516 1.141e-07 -0.960293686 1.142e-07 -0.968583161 1.143e-07 -0.975916762 \
    1.144e-07 -0.982287251 1.145e-07 -0.987688341 1.146e-07 -0.992114701 1.147e-07 -0.995561965 \
    1.148e-07 -0.998026728 1.149e-07 -0.99950656 1.15e-07 -1 1.151e-07 -0.99950656 \
    1.152e-07 -0.998026728 1.153e-07 -0.995561965 1.154e-07 -0.992114701 1.155e-07 -0.987688341 \
    1.156e-07 -0.982287251 1.157e-07 -0.975916762 1.158e-07 -0.968583161 1.159e-07 -0.960293686 \
    1.16e-07 -0.951056516 1.161e-07 -0.940880769 1.162e-07 -0.929776486 1.163e-07 -0.917754626 \
    1.164e-07 -0.904827052 1.165e-07 -0.891006524 1.166e-07 -0.87630668 1.167e-07 -0.860742027 \
    1.168e-07 -0.844327926 1.169e-07 -0.827080574 1.17e-07 -0.809016994 1.171e-07 -0.790155012 \
    1.172e-07 -0.770513243 1.173e-07 -0.75011107 1.174e-07 -0.728968627 1.175e-07 -0.707106781 \
    1.176e-07 -0.684547106 1.177e-07 -0.661311865 1.178e-07 -0.63742399 1.179e-07 -0.612907054 \
    1.18e-07 -0.587785252 1.181e-07 -0.562083378 1.182e-07 -0.535826795 1.183e-07 -0.509041416 \
    1.184e-07 -0.481753674 1.185e-07 -0.4539905 1.186e-07 -0.425779292 1.187e-07 -0.397147891 \
    1.188e-07 -0.368124553 1.189e-07 -0.33873792 1.19e-07 -0.309016994 1.191e-07 -0.278991106 \
    1.192e-07 -0.248689887 1.193e-07 -0.218143241 1.194e-07 -0.187381315 1.195e-07 -0.156434465 \
    1.196e-07 -0.125333234 1.197e-07 -0.0941083133 1.198e-07 -0.0627905195 1.199e-07 -0.0314107591 \
    1.2e-07 0 1.201e-07 0.0314107591 1.202e-07 0.0627905195 1.203e-07 0.0941083133 \
    1.204e-07 0.125333234 1.205e-07 0.156434465 1.206e-07 0.187381315 1.207e-07 0.218143241 \
    1.208e-07 0.248689887 1.209e-07 0.278991106 1.21e-07 0.309016994 1.211e-07 0.33873792 \
    1.212e-07 0.368124553 1.213e-07 0.397147891 1.214e-07 0.425779292 1.215e-07 0.4539905 \
    1.216e-07 0.481753674 1.217e-07 0.509041416 1.218e-07 0.535826795 1.219e-07 0.562083378 \
    1.22e-07 0.587785252 1.221e-07 0.612907054 1.222e-07 0.63742399 1.223e-07 0.661311865 \
    1.224e-07 0.684547106 1.225e-07 0.707106781 1.226e-07 0.728968627 1.227e-07 0.75011107 \
    1.228e-07 0.770513243 1.229e-07 0.790155012 1.23e-07 0.809016994 1.231e-07 0.827080574 \
    1.232e-07 0.844327926 1.233e-07 0.860742027 1.234e-07 0.87630668 1.235e-07 0.891006524 \
    1.236e-07 0.904827052 1.237e-07 0.917754626 1.238e-07 0.929776486 1.239e-07 0.940880769 \
    1.24e-07 0.951056516 1.241e-07 0.960293686 1.242e-07 0.968583161 1.243e-07 0.975916762 \
    1.244e-07 0.982287251 1.245e-07 0.987688341 1.246e-07 0.992114701 1.247e-07 0.995561965 \
    1.248e-07 0.998026728 1.249e-07 0.99950656 1.25e-07 1 1.251e-07 0.99950656 \
    1.252e-07 0.998026728 1.253e-07 0.995561965 1.254e-07 0.992114701 1.255e-07 0.987688341 \
    1.256e-07 0.982287251 1.257e-07 0.975916762 1.258e-07 0.968583161 1.259e-07 0.960293686 \
    1.26e-07 0.951056516 1.261e-07 0.940880769 1.262e-07 0.929776486 1.263e-07 0.917754626 \
    1.264e-07 0.904827052 1.265e-07 0.891006524 1.266e-07 0.87630668 1.267e-07 0.860742027 \
    1.268e-07 0.844327926 1.269e-07 0.827080574 1.27e-07 0.809016994 1.271e-07 0.790155012 \
    1.272e-07 0.770513243 1.273e-07 0.75011107 1.274e-07 0.728968627 1.275e-07 0.707106781 \
    1.276e-07 0.684547106 1.277e-07 0.661311865 1.278e-07 0.63742399 1.279e-07 0.612907054 \
    1.28e-07 0.587785252 1.281e-07 0.562083378 1.282e-07 0.535826795 1.283e-07 0.509041416 \
    1.284e-07 0.481753674 1.285e-07 0.4539905 1.286e-07 0.425779292 1.287e-07 0.397147891 \
    1.288e-07 0.368124553 1.289e-07 0.33873792 1.29e-07 0.309016994 1.291e-07 0.278991106 \
    1.292e-07 0.248689887 1.293e-07 0.218143241 1.294e-07 0.187381315 1.295e-07 0.156434465 \
    1.296e-07 0.125333234 1.297e-07 0.0941083133 1.298e-07 0.0627905195 1.299e-07 0.0314107591 \
    1.3e-07 0 1.301e-07 -0.0314107591 1.302e-07 -0.0627905195 1.303e-07 -0.0941083133 \
    1.304e-07 -0.125333234 1.305e-07 -0.156434465 1.306e-07 -0.187381315 1.307e-07 -0.218143241 \
    1.308e-07 -0.248689887 1.309e-07 -0.278991106 1.31e-07 -0.309016994 1.311e-07 -0.33873792 \
    1.312e-07 -0.368124553 1.313e-07 -0.397147891 1.314e-07 -0.425779292 1.315e-07 -0.4539905 \
    1.316e-07 -0.481753674 1.317e-07 -0.509041416 1.318e-07 -0.535826795 1.319e-07 -0.562083378 \
    1.32e-07 -0.587785252 1.321e-07 -0.612907054 1.322e-07 -0.63742399 1.323e-07 -0.661311865 \
    1.324e-07 -0.684547106 1.325e-07 -0.707106781 1.326e-07 -0.728968627 1.327e-07 -0.75011107 \
    1.328e-07 -0.770513243 1.329e-07 -0.790155012 1.33e-07 -0.809016994 1.331e-07 -0.827080574 \
    1.332e-07 -0.844327926 1.333e-07 -0.860742027 1.334e-07 -0.87630668 1.335e-07 -0.891006524 \
    1.336e-07 -0.904827052 1.337e-07 -0.917754626 1.338e-07 -0.929776486 1.339e-07 -0.940880769 \
    1.34e-07 -0.951056516 1.341e-07 -0.960293686 1.342e-07 -0.968583161 1.343e-07 -0.975916762 \
    1.344e-07 -0.982287251 1.345e-07 -0.987688341 1.346e-07 -0.992114701 1.347e-07 -0.995561965 \
    1.348e-07 -0.998026728 1.349e-07 -0.99950656 1.35e-07 -1 1.351e-07 -0.99950656 \
    1.352e-07 -0.998026728 1.353e-07 -0.995561965 1.354e-07 -0.992114701 1.355e-07 -0.987688341 \
    1.356e-07 -0.982287251 1.357e-07 -0.975916762 1.358e-07 -0.968583161 1.359e-07 -0.960293686 \
    1.36e-07 -0.951056516 1.361e-07 -0.940880769 1.362e-07 -0.929776486 1.363e-07 -0.917754626 \
    1.364e-07 -0.904827052 1.365e-07 -0.891006524 1.366e-07 -0.87630668 1.367e-07 -0.860742027 \
    1.368e-07 -0.844327926 1.369e-07 -0.827080574 1.37e-07 -0.809016994 1.371e-07 -0.790155012 \
    1.372e-07 -0.770513243 1.373e-07 -0.75011107 1.374e-07 -0.728968627 1.375e-07 -0.707106781 \
    1.376e-07 -0.684547106 1.377e-07 -0.661311865 1.378e-07 -0.63742399 1.379e-07 -0.612907054 \
    1.38e-07 -0.587785252 1.381e-07 -0.562083378 1.382e-07 -0.535826795 1.383e-07 -0.509041416 \
    1.384e-07 -0.481753674 1.385e-07 -0.4539905 1.386e-07 -0.425779292 1.387e-07 -0.397147891 \
    1.388e-07 -0.368124553 1.389e-07 -0.33873792 1.39e-07 -0.309016994 1.391e-07 -0.278991106 \
    1.392e-07 -0.248689887 1.393e-07 -0.218143241 1.394e-07 -0.187381315 1.395e-07 -0.156434465 \
    1.396e-07 -0.125333234 1.397e-07 -0.0941083133 1.398e-07 -0.0627905195 1.399e-07 -0.0314107591 \
    1.4e-07 0 1.401e-07 0.0314107591 1.402e-07 0.0627905195 1.403e-07 0.0941083133 \
    1.404e-07 0.125333234 1.405e-07 0.156434465 1.406e-07 0.187381315 1.407e-07 0.218143241 \
    1.408e-07 0.248689887 1.409e-07 0.278991106 1.41e-07 0.309016994 1.411e-07 0.33873792 \
    1.412e-07 0.368124553 1.413e-07 0.397147891 1.414e-07 0.425779292 1.415e-07 0.4539905 \
    1.416e-07 0.481753674 1.417e-07 0.509041416 1.418e-07 0.535826795 1.419e-07 0.562083378 \
    1.42e-07 0.587785252 1.421e-07 0.612907054 1.422e-07 0.63742399 1.423e-07 0.661311865 \
    1.424e-07 0.684547106 1.425e-07 0.707106781 1.426e-07 0.728968627 1.427e-07 0.75011107 \
    1.428e-07 0.770513243 1.429e-07 0.790155012 1.43e-07 0.809016994 1.431e-07 0.827080574 \
    1.432e-07 0.844327926 1.433e-07 0.860742027 1.434e-07 0.87630668 1.435e-07 0.891006524 \
    1.436e-07 0.904827052 1.437e-07 0.917754626 1.438e-07 0.929776486 1.439e-07 0.940880769 \
    1.44e-07 0.951056516 1.441e-07 0.960293686 1.442e-07 0.968583161 1.443e-07 0.975916762 \
    1.444e-07 0.982287251 1.445e-07 0.987688341 1.446e-07 0.992114701 1.447e-07 0.995561965 \
    1.448e-07 0.998026728 1.449e-07 0.99950656 1.45e-07 1 1.451e-07 0.99950656 \
    1.452e-07 0.998026728 1.453e-07 0.995561965 1.454e-07 0.992114701 1.455e-07 0.987688341 \
    1.456e-07 0.982287251 1.457e-07 0.975916762 1.458e-07 0.968583161 1.459e-07 0.960293686 \
    1.46e-07 0.951056516 1.461e-07 0.940880769 1.462e-07 0.929776486 1.463e-07 0.917754626 \
    1.464e-07 0.904827052 1.465e-07 0.891006524 1.466e-07 0.87630668 1.467e-07 0.860742027 \
    1.468e-07 0.844327926 1.469e-07 0.827080574 1.47e-07 0.809016994 1.471e-07 0.790155012 \
    1.472e-07 0.770513243 1.473e-07 0.75011107 1.474e-07 0.728968627 1.475e-07 0.707106781 \
    1.476e-07 0.684547106 1.477e-07 0.661311865 1.478e-07 0.63742399 1.479e-07 0.612907054 \
    1.48e-07 0.587785252 1.481e-07 0.562083378 1.482e-07 0.535826795 1.483e-07 0.509041416 \
    1.484e-07 0.481753674 1.485e-07 0.4539905 1.486e-07 0.425779292 1.487e-07 0.397147891 \
    1.488e-07 0.368124553 1.489e-07 0.33873792 1.49e-07 0.309016994 1.491e-07 0.278991106 \
    1.492e-07 0.248689887 1.493e-07 0.218143241 1.494e-07 0.187381315 1.495e-07 0.156434465 \
    1.496e-07 0.125333234 1.497e-07 0.0941083133 1.498e-07 0.0627905195 1.499e-07 0.0314107591 \
    1.5e-07 0 1.501e-07 -0.0314107591 1.502e-07 -0.0627905195 1.503e-07 -0.0941083133 \
    1.504e-07 -0.125333234 1.505e-07 -0.156434465 1.506e-07 -0.187381315 1.507e-07 -0.218143241 \
    1.508e-07 -0.248689887 1.509e-07 -0.278991106 1.51e-07 -0.309016994 1.511e-07 -0.33873792 \
    1.512e-07 -0.368124553 1.513e-07 -0.397147891 1.514e-07 -0.425779292 1.515e-07 -0.4539905 \
    1.516e-07 -0.481753674 1.517e-07 -0.509041416 1.518e-07 -0.535826795 1.519e-07 -0.562083378 \
    1.52e-07 -0.587785252 1.521e-07 -0.612907054 1.522e-07 -0.63742399 1.523e-07 -0.661311865 \
    1.524e-07 -0.684547106 1.525e-07 -0.707106781 1.526e-07 -0.728968627 1.527e-07 -0.75011107 \
    1.528e-07 -0.770513243 1.529e-07 -0.790155012 1.53e-07 -0.809016994 1.531e-07 -0.827080574 \
    1.532e-07 -0.844327926 1.533e-07 -0.860742027 1.534e-07 -0.87630668 1.535e-07 -0.891006524 \
    1.536e-07 -0.904827052 1.537e-07 -0.917754626 1.538e-07 -0.929776486 1.539e-07 -0.940880769 \
    1.54e-07 -0.951056516 1.541e-07 -0.960293686 1.542e-07 -0.968583161 1.543e-07 -0.975916762 \
    1.544e-07 -0.982287251 1.545e-07 -0.987688341 1.546e-07 -0.992114701 1.547e-07 -0.995561965 \
    1.548e-07 -0.998026728 1.549e-07 -0.99950656 1.55e-07 -1 1.551e-07 -0.99950656 \
    1.552e-07 -0.998026728 1.553e-07 -0.995561965 1.554e-07 -0.992114701 1.555e-07 -0.987688341 \
    1.556e-07 -0.982287251 1.557e-07 -0.975916762 1.558e-07 -0.968583161 1.559e-07 -0.960293686 \
    1.56e-07 -0.951056516 1.561e-07 -0.940880769 1.562e-07 -0.929776486 1.563e-07 -0.917754626 \
    1.564e-07 -0.904827052 1.565e-07 -0.891006524 1.566e-07 -0.87630668 1.567e-07 -0.860742027 \
    1.568e-07 -0.844327926 1.569e-07 -0.827080574 1.57e-07 -0.809016994 1.571e-07 -0.790155012 \
    1.572e-07 -0.770513243 1.573e-07 -0.75011107 1.574e-07 -0.728968627 1.575e-07 -0.707106781 \
    1.576e-07 -0.684547106 1.577e-07 -0.661311865 1.578e-07 -0.63742399 1.579e-07 -0.612907054 \
    1.58e-07 -0.587785252 1.581e-07 -0.562083378 1.582e-07 -0.535826795 1.583e-07 -0.509041416 \
    1.584e-07 -0.481753674 1.585e-07 -0.4539905 1.586e-07 -0.425779292 1.587e-07 -0.397147891 \
    1.588e-07 -0.368124553 1.589e-07 -0.33873792 1.59e-07 -0.309016994 1.591e-07 -0.278991106 \
    1.592e-07 -0.248689887 1.593e-07 -0.218143241 1.594e-07 -0.187381315 1.595e-07 -0.156434465 \
    1.596e-07 -0.125333234 1.597e-07 -0.0941083133 1.598e-07 -0.0627905195 1.599e-07 -0.0314107591 \
    1.6e-07 0 1.601e-07 0.0314107591 1.602e-07 0.0627905195 1.603e-07 0.0941083133 \
    1.604e-07 0.125333234 1.605e-07 0.156434465 1.606e-07 0.187381315 1.607e-07 0.218143241 \
    1.608e-07 0.248689887 1.609e-07 0.278991106 1.61e-07 0.309016994 1.611e-07 0.33873792 \
    1.612e-07 0.368124553 1.613e-07 0.397147891 1.614e-07 0.425779292 1.615e-07 0.4539905 \
    1.616e-07 0.481753674 1.617e-07 0.509041416 1.618e-07 0.535826795 1.619e-07 0.562083378 \
    1.62e-07 0.587785252 1.621e-07 0.612907054 1.622e-07 0.63742399 1.623e-07 0.661311865 \
    1.624e-07 0.684547106 1.625e-07 0.707106781 1.626e-07 0.728968627 1.627e-07 0.75011107 \
    1.628e-07 0.770513243 1.629e-07 0.790155012 1.63e-07 0.809016994 1.631e-07 0.827080574 \
    1.632e-07 0.844327926 1.633e-07 0.860742027 1.634e-07 0.87630668 1.635e-07 0.891006524 \
    1.636e-07 0.904827052 1.637e-07 0.917754626 1.638e-07 0.929776486 1.639e-07 0.940880769 \
    1.64e-07 0.951056516 1.641e-07 0.960293686 1.642e-07 0.968583161 1.643e-07 0.975916762 \
    1.644e-07 0.982287251 1.645e-07 0.987688341 1.646e-07 0.992114701 1.647e-07 0.995561965 \
    1.648e-07 0.998026728 1.649e-07 0.99950656 1.65e-07 1 1.651e-07 0.99950656 \
    1.652e-07 0.998026728 1.653e-07 0.995561965 1.654e-07 0.992114701 1.655e-07 0.987688341 \
    1.656e-07 0.982287251 1.657e-07 0.975916762 1.658e-07 0.968583161 1.659e-07 0.960293686 \
    1.66e-07 0.951056516 1.661e-07 0.940880769 1.662e-07 0.929776486 1.663e-07 0.917754626 \
    1.664e-07 0.904827052 1.665e-07 0.891006524 1.666e-07 0.87630668 1.667e-07 0.860742027 \
    1.668e-07 0.844327926 1.669e-07 0.827080574 1.67e-07 0.809016994 1.671e-07 0.790155012 \
    1.672e-07 0.770513243 1.673e-07 0.75011107 1.674e-07 0.728968627 1.675e-07 0.707106781 \
    1.676e-07 0.684547106 1.677e-07 0.661311865 1.678e-07 0.63742399 1.679e-07 0.612907054 \
    1.68e-07 0.587785252 1.681e-07 0.562083378 1.682e-07 0.535826795 1.683e-07 0.509041416 \
    1.684e-07 0.481753674 1.685e-07 0.4539905 1.686e-07 0.425779292 1.687e-07 0.397147891 \
    1.688e-07 0.368124553 1.689e-07 0.33873792 1.69e-07 0.309016994 1.691e-07 0.278991106 \
    1.692e-07 0.248689887 1.693e-07 0.218143241 1.694e-07 0.187381315 1.695e-07 0.156434465 \
    1.696e-07 0.125333234 1.697e-07 0.0941083133 1.698e-07 0.0627905195 1.699e-07 0.0314107591 \
    1.7e-07 0 1.701e-07 -0.0314107591 1.702e-07 -0.0627905195 1.703e-07 -0.0941083133 \
    1.704e-07 -0.125333234 1.705e-07 -0.156434465 1.706e-07 -0.187381315 1.707e-07 -0.218143241 \
    1.708e-07 -0.248689887 1.709e-07 -0.278991106 1.71e-07 -0.309016994 1.711e-07 -0.33873792 \
    1.712e-07 -0.368124553 1.713e-07 -0.397147891 1.714e-07 -0.425779292 1.715e-07 -0.4539905 \
    1.716e-07 -0.481753674 1.717e-07 -0.509041416 1.718e-07 -0.535826795 1.719e-07 -0.562083378 \
    1.72e-07 -0.587785252 1.721e-07 -0.612907054 1.722e-07 -0.63742399 1.723e-07 -0.661311865 \
    1.724e-07 -0.684547106 1.725e-07 -0.707106781 1.726e-07 -0.728968627 1.727e-07 -0.75011107 \
    1.728e-07 -0.770513243 1.729e-07 -0.790155012 1.73e-07 -0.809016994 1.731e-07 -0.827080574 \
    1.732e-07 -0.844327926 1.733e-07 -0.860742027 1.734e-07 -0.87630668 1.735e-07 -0.891006524 \
    1.736e-07 -0.904827052 1.737e-07 -0.917754626 1.738e-07 -0.929776486 1.739e-07 -0.940880769 \
    1.74e-07 -0.951056516 1.741e-07 -0.960293686 1.742e-07 -0.968583161 1.743e-07 -0.975916762 \
    1.744e-07 -0.982287251 1.745e-07 -0.987688341 1.746e-07 -0.992114701 1.747e-07 -0.995561965 \
    1.748e-07 -0.998026728 1.749e-07 -0.99950656 1.75e-07 -1 1.751e-07 -0.99950656 \
    1.752e-07 -0.998026728 1.753e-07 -0.995561965 1.754e-07 -0.992114701 1.755e-07 -0.987688341 \
    1.756e-07 -0.982287251 1.757e-07 -0.975916762 1.758e-07 -0.968583161 1.759e-07 -0.960293686 \
    1.76e-07 -0.951056516 1.761e-07 -0.940880769 1.762e-07 -0.929776486 1.763e-07 -0.917754626 \
    1.764e-07 -0.904827052 1.765e-07 -0.891006524 1.766e-07 -0.87630668 1.767e-07 -0.860742027 \
    1.768e-07 -0.844327926 1.769e-07 -0.827080574 1.77e-07 -0.809016994 1.771e-07 -0.790155012 \
    1.772e-07 -0.770513243 1.773e-07 -0.75011107 1.774e-07 -0.728968627 1.775e-07 -0.707106781 \
    1.776e-07 -0.684547106 1.777e-07 -0.661311865 1.778e-07 -0.63742399 1.779e-07 -0.612907054 \
    1.78e-07 -0.587785252 1.781e-07 -0.562083378 1.782e-07 -0.535826795 1.783e-07 -0.509041416 \
    1.784e-07 -0.481753674 1.785e-07 -0.4539905 1.786e-07 -0.425779292 1.787e-07 -0.397147891 \
    1.788e-07 -0.368124553 1.789e-07 -0.33873792 1.79e-07 -0.309016994 1.791e-07 -0.278991106 \
    1.792e-07 -0.248689887 1.793e-07 -0.218143241 1.794e-07 -0.187381315 1.795e-07 -0.156434465 \
    1.796e-07 -0.125333234 1.797e-07 -0.0941083133 1.798e-07 -0.0627905195 1.799e-07 -0.0314107591 \
    1.8e-07 0 1.801e-07 0.0314107591 1.802e-07 0.0627905195 1.803e-07 0.0941083133 \
    1.804e-07 0.125333234 1.805e-07 0.156434465 1.806e-07 0.187381315 1.807e-07 0.218143241 \
    1.808e-07 0.248689887 1.809e-07 0.278991106 1.81e-07 0.309016994 1.811e-07 0.33873792 \
    1.812e-07 0.368124553 1.813e-07 0.397147891 1.814e-07 0.425779292 1.815e-07 0.4539905 \
    1.816e-07 0.481753674 1.817e-07 0.509041416 1.818e-07 0.535826795 1.819e-07 0.562083378 \
    1.82e-07 0.587785252 1.821e-07 0.612907054 1.822e-07 0.63742399 1.823e-07 0.661311865 \
    1.824e-07 0.684547106 1.825e-07 0.707106781 1.826e-07 0.728968627 1.827e-07 0.75011107 \
    1.828e-07 0.770513243 1.829e-07 0.790155012 1.83e-07 0.809016994 1.831e-07 0.827080574 \
    1.832e-07 0.844327926 1.833e-07 0.860742027 1.834e-07 0.87630668 1.835e-07 0.891006524 \
    1.836e-07 0.904827052 1.837e-07 0.917754626 1.838e-07 0.929776486 1.839e-07 0.940880769 \
    1.84e-07 0.951056516 1.841e-07 0.960293686 1.842e-07 0.968583161 1.843e-07 0.975916762 \
    1.844e-07 0.982287251 1.845e-07 0.987688341 1.846e-07 0.992114701 1.847e-07 0.995561965 \
    1.848e-07 0.998026728 1.849e-07 0.99950656 1.85e-07 1 1.851e-07 0.99950656 \
    1.852e-07 0.998026728 1.853e-07 0.995561965 1.854e-07 0.992114701 1.855e-07 0.987688341 \
    1.856e-07 0.982287251 1.857e-07 0.975916762 1.858e-07 0.968583161 1.859e-07 0.960293686 \
    1.86e-07 0.951056516 1.861e-07 0.940880769 1.862e-07 0.929776486 1.863e-07 0.917754626 \
    1.864e-07 0.904827052 1.865e-07 0.891006524 1.866e-07 0.87630668 1.867e-07 0.860742027 \
    1.868e-07 0.844327926 1.869e-07 0.827080574 1.87e-07 0.809016994 1.871e-07 0.790155012 \
    1.872e-07 0.770513243 1.873e-07 0.75011107 1.874e-07 0.728968627 1.875e-07 0.707106781 \
    1.876e-07 0.684547106 1.877e-07 0.661311865 1.878e-07 0.63742399 1.879e-07 0.612907054 \
    1.88e-07 0.587785252 1.881e-07 0.562083378 1.882e-07 0.535826795 1.883e-07 0.509041416 \
    1.884e-07 0.481753674 1.885e-07 0.4539905 1.886e-07 0.425779292 1.887e-07 0.397147891 \
    1.888e-07 0.368124553 1.889e-07 0.33873792 1.89e-07 0.309016994 1.891e-07 0.278991106 \
    1.892e-07 0.248689887 1.893e-07 0.218143241 1.894e-07 0.187381315 1.895e-07 0.156434465 \
    1.896e-07 0.125333234 1.897e-07 0.0941083133 1.898e-07 0.0627905195 1.899e-07 0.0314107591 \
    1.9e-07 0 1.901e-07 -0.0314107591 1.902e-07 -0.0627905195 1.903e-07 -0.0941083133 \
    1.904e-07 -0.125333234 1.905e-07 -0.156434465 1.906e-07 -0.187381315 1.907e-07 -0.218143241 \
    1.908e-07 -0.248689887 1.909e-07 -0.278991106 1.91e-07 -0.309016994 1.911e-07 -0.33873792 \
    1.912e-07 -0.368124553 1.913e-07 -0.397147891 1.914e-07 -0.425779292 1.915e-07 -0.4539905 \
    1.916e-07 -0.481753674 1.917e-07 -0.509041416 1.918e-07 -0.535826795 1.919e-07 -0.562083378 \
    1.92e-07 -0.587785252 1.921e-07 -0.612907054 1.922e-07 -0.63742399 1.923e-07 -0.661311865 \
    1.924e-07 -0.684547106 1.925e-07 -0.707106781 1.926e-07 -0.728968627 1.927e-07 -0.75011107 \
    1.928e-07 -0.770513243 1.929e-07 -0.790155012 1.93e-07 -0.809016994 1.931e-07 -0.827080574 \
    1.932e-07 -0.844327926 1.933e-07 -0.860742027 1.934e-07 -0.87630668 1.935e-07 -0.891006524 \
    1.936e-07 -0.904827052 1.937e-07 -0.917754626 1.938e-07 -0.929776486 1.939e-07 -0.940880769 \
    1.94e-07 -0.951056516 1.941e-07 -0.960293686 1.942e-07 -0.968583161 1.943e-07 -0.975916762 \
    1.944e-07 -0.982287251 1.945e-07 -0.987688341 1.946e-07 -0.992114701 1.947e-07 -0.995561965 \
    1.948e-07 -0.998026728 1.949e-07 -0.99950656 1.95e-07 -1 1.951e-07 -0.99950656 \
    1.952e-07 -0.998026728 1.953e-07 -0.995561965 1.954e-07 -0.992114701 1.955e-07 -0.987688341 \
    1.956e-07 -0.982287251 1.957e-07 -0.975916762 1.958e-07 -0.968583161 1.959e-07 -0.960293686 \
    1.96e-07 -0.951056516 1.961e-07 -0.940880769 1.962e-07 -0.929776486 1.963e-07 -0.917754626 \
    1.964e-07 -0.904827052 1.965e-07 -0.891006524 1.966e-07 -0.87630668 1.967e-07 -0.860742027 \
    1.968e-07 -0.844327926 1.969e-07 -0.827080574 1.97e-07 -0.809016994 1.971e-07 -0.790155012 \
    1.972e-07 -0.770513243 1.973e-07 -0.75011107 1.974e-07 -0.728968627 1.975e-07 -0.707106781 \
    1.976e-07 -0.684547106 1.977e-07 -0.661311865 1.978e-07 -0.63742399 1.979e-07 -0.612907054 \
    1.98e-07 -0.587785252 1.981e-07 -0.562083378 1.982e-07 -0.535826795 1.983e-07 -0.509041416 \
    1.984e-07 -0.481753674 1.985e-07 -0.4539905 1.986e-07 -0.425779292 1.987e-07 -0.397147891 \
    1.988e-07 -0.368124553 1.989e-07 -0.33873792 1.99e-07 -0.309016994 1.991e-07 -0.278991106 \
    1.992e-07 -0.248689887 1.993e-07 -0.218143241 1.994e-07 -0.187381315 1.995e-07 -0.156434465 \
    1.996e-07 -0.125333234 1.997e-07 -0.0941083133 1.998e-07 -0.0627905195 1.999e-07 -0.0314107591 \
    2e-07 0 ]

tran tran stop=2e-07 maxstep=1e-10 errpreset=conservative

save n_p X1:p X1.ws
