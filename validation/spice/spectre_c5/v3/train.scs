// train.scs - GENERATED by validation/c5/make_deck.py; do not edit.
// C5 tier 1: 16 ecfet_v3 synapses replaying the write pulses a NeuroVAT
// stream-mode STDP run (masquelier.run, EcfetV3Array, physical time) applied;
// 3608 pulses, t_stop 4.06 s

simulator lang=spectre
global 0

ahdl_include "../../../../verilog/ecfet_v3.va"

simOpts options reltol=1e-6 vabstol=1e-12 iabstol=1e-18 gmin=1e-15 temp=27
saveOpts options save=selected

vread (n_in 0) vsource dc=0.01 type=dc   // one read bias for every synapse

X0 (n_in 0 n_ig0 n_rm0) ecfet_v3 Rinit=1642.09131525 A_stdp=0
ig0 (0 n_ig0) isource type=pwl wave=[ 0.0000000 0 0.0200000 0 0.0200010 -9.53107878e-10 0.0300000 -9.53107878e-10 \
    0.0300010 1.34222199e-09 0.0400000 1.34222199e-09 0.0400010 2.30904264e-10 0.0500000 2.30904264e-10 \
    0.0500010 0 0.0700000 0 0.0700010 -1.00455239e-09 0.0800000 -1.00455239e-09 \
    0.0800010 1.36367175e-09 0.0900000 1.36367175e-09 0.0900010 5.57795028e-11 0.1000000 5.57795028e-11 \
    0.1000010 0 0.1200000 0 0.1200010 -1.07438711e-09 0.1300000 -1.07438711e-09 \
    0.1300010 7.88511498e-10 0.1400000 7.88511498e-10 0.1400010 0 0.1700000 0 \
    0.1700010 -7.98619788e-10 0.1800000 -7.98619788e-10 0.1800010 9.59434849e-10 0.1900000 9.59434849e-10 \
    0.1900010 -1.15336383e-10 0.2000000 -1.15336383e-10 0.2000010 0 0.2200000 0 \
    0.2200010 -9.31555868e-10 0.2300000 -9.31555868e-10 0.2300010 1.38036686e-09 0.2400000 1.38036686e-09 \
    0.2400010 0 0.2600000 0 0.2600010 -1.14415742e-09 0.2700000 -1.14415742e-09 \
    0.2700010 1.38100368e-09 0.2800000 1.38100368e-09 0.2800010 -2.30329016e-10 0.2900000 -2.30329016e-10 \
    0.2900010 -1.09033245e-09 0.3000000 -1.09033245e-09 0.3000010 7.88676827e-10 0.3100000 7.88676827e-10 \
    0.3100010 -1.19252051e-09 0.3200000 -1.19252051e-09 0.3200010 0 0.3300000 0 \
    0.3300010 6.2087302e-10 0.3400000 6.2087302e-10 0.3400010 -1.16919575e-09 0.3500000 -1.16919575e-09 \
    0.3500010 0 0.3600000 0 0.3600010 5.73833271e-10 0.3700000 5.73833271e-10 \
    0.3700010 -1.05935211e-09 0.3800000 -1.05935211e-09 0.3800010 1.03795808e-09 0.3900000 1.03795808e-09 \
    0.3900010 -9.96375636e-10 0.4000000 -9.96375636e-10 0.4000010 8.28956632e-10 0.4100000 8.28956632e-10 \
    0.4100010 -9.690895e-10 0.4200000 -9.690895e-10 0.4200010 8.71238239e-10 0.4300000 8.71238239e-10 \
    0.4300010 0 0.4400000 0 0.4400010 7.59347932e-10 0.4500000 7.59347932e-10 \
    0.4500010 0 0.4900000 0 0.4900010 1.93612475e-10 0.5000000 1.93612475e-10 \
    0.5000010 0 0.5400000 0 0.5400010 -1.18936893e-09 0.5500000 -1.18936893e-09 \
    0.5500010 7.2432808e-10 0.5600000 7.2432808e-10 0.5600010 0 0.5700000 0 \
    0.5700010 -6.69680764e-10 0.5800000 -6.69680764e-10 0.5800010 1.08938625e-09 0.5900000 1.08938625e-09 \
    0.5900010 -9.89788697e-10 0.6000000 -9.89788697e-10 0.6000010 8.00994413e-10 0.6100000 8.00994413e-10 \
    0.6100010 -1.09792492e-09 0.6200000 -1.09792492e-09 0.6200010 8.8133404e-10 0.6300000 8.8133404e-10 \
    0.6300010 -9.13404479e-10 0.6400000 -9.13404479e-10 0.6400010 8.403867e-10 0.6500000 8.403867e-10 \
    0.6500010 0 0.6800000 0 0.6800010 -1.04246725e-09 0.6900000 -1.04246725e-09 \
    0.6900010 1.05923039e-09 0.7000000 1.05923039e-09 0.7000010 0 0.7300000 0 \
    0.7300010 -6.53157519e-10 0.7400000 -6.53157519e-10 0.7400010 1.42756026e-09 0.7500000 1.42756026e-09 \
    0.7500010 0 0.7700000 0 0.7700010 5.97612069e-10 0.7800000 5.97612069e-10 \
    0.7800010 0 0.7900000 0 0.7900010 2.45729063e-10 0.8000000 2.45729063e-10 \
    0.8000010 0 0.8200000 0 0.8200010 5.91946745e-10 0.8300000 5.91946745e-10 \
    0.8300010 -9.42577902e-10 0.8400000 -9.42577902e-10 0.8400010 9.66012159e-10 0.8500000 9.66012159e-10 \
    0.8500010 0 0.8800000 0 0.8800010 -6.24036245e-10 0.8900000 -6.24036245e-10 \
    0.8900010 8.37136217e-10 0.9000000 8.37136217e-10 0.9000010 -1.02522637e-09 0.9100000 -1.02522637e-09 \
    0.9100010 2.21382706e-11 0.9200000 2.21382706e-11 0.9200010 9.54073871e-11 0.9300000 9.54073871e-11 \
    0.9300010 -2.8974202e-11 0.9400000 -2.8974202e-11 0.9400010 1.4356045e-09 0.9500000 1.4356045e-09 \
    0.9500010 0 0.9700000 0 0.9700010 -1.21581084e-09 0.9800000 -1.21581084e-09 \
    0.9800010 1.46862867e-09 0.9900000 1.46862867e-09 0.9900010 3.46048693e-10 1.0000000 3.46048693e-10 \
    1.0000010 -1.1952313e-09 1.0100000 -1.1952313e-09 1.0100010 1.47893457e-10 1.0200000 1.47893457e-10 \
    1.0200010 1.04465662e-09 1.0300000 1.04465662e-09 1.0300010 -9.15521089e-10 1.0400000 -9.15521089e-10 \
    1.0400010 1.34777023e-09 1.0500000 1.34777023e-09 1.0500010 -1.08501499e-09 1.0600000 -1.08501499e-09 \
    1.0600010 8.97139217e-10 1.0700000 8.97139217e-10 1.0700010 -6.74653553e-10 1.0800000 -6.74653553e-10 \
    1.0800010 1.20232117e-09 1.0900000 1.20232117e-09 1.0900010 4.19136179e-10 1.1000000 4.19136179e-10 \
    1.1000010 0 1.1400000 0 1.1400010 -7.07061616e-10 1.1500000 -7.07061616e-10 \
    1.1500010 1.11073201e-09 1.1600000 1.11073201e-09 1.1600010 0 1.1700000 0 \
    1.1700010 6.89850926e-10 1.1800000 6.89850926e-10 1.1800010 0 1.1900000 0 \
    1.1900010 -1.28020575e-09 1.2000000 -1.28020575e-09 1.2000010 8.58809218e-10 1.2100000 8.58809218e-10 \
    1.2100010 4.42705297e-10 1.2200000 4.42705297e-10 1.2200010 0 1.2400000 0 \
    1.2400010 -9.61731503e-10 1.2500000 -9.61731503e-10 1.2500010 1.09096228e-09 1.2600000 1.09096228e-09 \
    1.2600010 -1.27196222e-09 1.2700000 -1.27196222e-09 1.2700010 1.40635396e-09 1.2800000 1.40635396e-09 \
    1.2800010 0 1.3200000 0 1.3200010 -1.05283761e-09 1.3300000 -1.05283761e-09 \
    1.3300010 0 1.3400000 0 1.3400010 3.93214056e-10 1.3500000 3.93214056e-10 \
    1.3500010 0 1.3600000 0 1.3600010 -1.17227808e-09 1.3700000 -1.17227808e-09 \
    1.3700010 1.30424499e-09 1.3800000 1.30424499e-09 1.3800010 -9.31635736e-10 1.3900000 -9.31635736e-10 \
    1.3900010 1.33170895e-09 1.4000000 1.33170895e-09 1.4000010 0 1.4100000 0 \
    1.4100010 -1.01594234e-09 1.4200000 -1.01594234e-09 1.4200010 0 1.4300000 0 \
    1.4300010 7.13282071e-10 1.4400000 7.13282071e-10 1.4400010 -1.06703318e-09 1.4500000 -1.06703318e-09 \
    1.4500010 1.11427372e-09 1.4600000 1.11427372e-09 1.4600010 0 1.4900000 0 \
    1.4900010 -8.37199917e-10 1.5000000 -8.37199917e-10 1.5000010 1.14089109e-09 1.5100000 1.14089109e-09 \
    1.5100010 0 1.5200000 0 1.5200010 2.2104292e-10 1.5300000 2.2104292e-10 \
    1.5300010 0 1.5400000 0 1.5400010 -1.13032464e-09 1.5500000 -1.13032464e-09 \
    1.5500010 9.09034879e-10 1.5600000 9.09034879e-10 1.5600010 0 1.5700000 0 \
    1.5700010 -1.08896821e-09 1.5800000 -1.08896821e-09 1.5800010 9.12077733e-10 1.5900000 9.12077733e-10 \
    1.5900010 1.03595478e-10 1.6000000 1.03595478e-10 1.6000010 0 1.6400000 0 \
    1.6400010 -1.13220741e-09 1.6500000 -1.13220741e-09 1.6500010 0 1.6600000 0 \
    1.6600010 6.93109373e-10 1.6700000 6.93109373e-10 1.6700010 0 1.6800000 0 \
    1.6800010 -1.14776337e-09 1.6900000 -1.14776337e-09 1.6900010 0 1.7000000 0 \
    1.7000010 1.03601261e-09 1.7100000 1.03601261e-09 1.7100010 0 1.7400000 0 \
    1.7400010 -1.04165764e-09 1.7500000 -1.04165764e-09 1.7500010 -4.53114788e-10 1.7600000 -4.53114788e-10 \
    1.7600010 1.41849542e-09 1.7700000 1.41849542e-09 1.7700010 -1.29846625e-09 1.7800000 -1.29846625e-09 \
    1.7800010 7.57056845e-10 1.7900000 7.57056845e-10 1.7900010 -1.09980763e-09 1.8000000 -1.09980763e-09 \
    1.8000010 8.27555407e-10 1.8100000 8.27555407e-10 1.8100010 5.83458749e-10 1.8200000 5.83458749e-10 \
    1.8200010 -1.01620816e-09 1.8300000 -1.01620816e-09 1.8300010 9.88205861e-10 1.8400000 9.88205861e-10 \
    1.8400010 0 1.8500000 0 1.8500010 -1.17195152e-09 1.8600000 -1.17195152e-09 \
    1.8600010 1.33212636e-09 1.8700000 1.33212636e-09 1.8700010 0 1.8800000 0 \
    1.8800010 -1.02420104e-09 1.8900000 -1.02420104e-09 1.8900010 1.40388427e-09 1.9000000 1.40388427e-09 \
    1.9000010 -1.07124546e-09 1.9100000 -1.07124546e-09 1.9100010 0 1.9200000 0 \
    1.9200010 1.42280687e-09 1.9300000 1.42280687e-09 1.9300010 0 1.9500000 0 \
    1.9500010 -1.06994121e-09 1.9600000 -1.06994121e-09 1.9600010 0 1.9700000 0 \
    1.9700010 -3.64367283e-10 1.9800000 -3.64367283e-10 1.9800010 -1.90658056e-10 1.9900000 -1.90658056e-10 \
    1.9900010 -2.5020436e-11 2.0000000 -2.5020436e-11 2.0000010 8.58342628e-10 2.0100000 8.58342628e-10 \
    2.0100010 -1.14249737e-09 2.0200000 -1.14249737e-09 2.0200010 1.36826107e-09 2.0300000 1.36826107e-09 \
    2.0300010 -9.31372121e-10 2.0400000 -9.31372121e-10 2.0400010 3.79694607e-10 2.0500000 3.79694607e-10 \
    2.0500010 9.01391717e-10 2.0600000 9.01391717e-10 2.0600010 0 2.0700000 0 \
    2.0700010 3.38994286e-10 2.0800000 3.38994286e-10 2.0800010 -1.01952679e-09 2.0900000 -1.01952679e-09 \
    2.0900010 1.30813527e-09 2.1000000 1.30813527e-09 2.1000010 -1.01671896e-09 2.1100000 -1.01671896e-09 \
    2.1100010 1.75129404e-10 2.1200000 1.75129404e-10 2.1200010 1.46917071e-09 2.1300000 1.46917071e-09 \
    2.1300010 3.62231518e-10 2.1400000 3.62231518e-10 2.1400010 0 2.1500000 0 \
    2.1500010 7.36471735e-10 2.1600000 7.36471735e-10 2.1600010 -1.0517909e-09 2.1700000 -1.0517909e-09 \
    2.1700010 1.49923364e-09 2.1800000 1.49923364e-09 2.1800010 0 2.1900000 0 \
    2.1900010 -2.63726692e-10 2.2000000 -2.63726692e-10 2.2000010 0 2.2400000 0 \
    2.2400010 2.77197084e-10 2.2500000 2.77197084e-10 2.2500010 0 2.2600000 0 \
    2.2600010 -1.0566177e-09 2.2700000 -1.0566177e-09 2.2700010 -3.52040825e-11 2.2800000 -3.52040825e-11 \
    2.2800010 7.77999166e-10 2.2900000 7.77999166e-10 2.2900010 0 2.3000000 0 \
    2.3000010 5.07823163e-10 2.3100000 5.07823163e-10 2.3100010 0 2.3200000 0 \
    2.3200010 -1.16243813e-09 2.3300000 -1.16243813e-09 2.3300010 0 2.3400000 0 \
    2.3400010 1.02709077e-09 2.3500000 1.02709077e-09 2.3500010 0 2.3700000 0 \
    2.3700010 4.57765546e-10 2.3800000 4.57765546e-10 2.3800010 0 2.3900000 0 \
    2.3900010 -2.19809656e-10 2.4000000 -2.19809656e-10 2.4000010 0 2.4200000 0 \
    2.4200010 -1.10299584e-09 2.4300000 -1.10299584e-09 2.4300010 1.01938539e-09 2.4400000 1.01938539e-09 \
    2.4400010 1.72756624e-10 2.4500000 1.72756624e-10 2.4500010 -9.38778846e-10 2.4600000 -9.38778846e-10 \
    2.4600010 2.54339882e-10 2.4700000 2.54339882e-10 2.4700010 0 2.4800000 0 \
    2.4800010 -3.1284548e-10 2.4900000 -3.1284548e-10 2.4900010 1.29101658e-09 2.5000000 1.29101658e-09 \
    2.5000010 3.12739844e-10 2.5100000 3.12739844e-10 2.5100010 0 2.5400000 0 \
    2.5400010 6.84979999e-10 2.5500000 6.84979999e-10 2.5500010 -1.2464768e-09 2.5600000 -1.2464768e-09 \
    2.5600010 0 2.5700000 0 2.5700010 1.37107353e-09 2.5800000 1.37107353e-09 \
    2.5800010 0 2.5900000 0 2.5900010 -1.32276303e-10 2.6000000 -1.32276303e-10 \
    2.6000010 0 2.6100000 0 2.6100010 2.21910522e-10 2.6200000 2.21910522e-10 \
    2.6200010 0 2.6400000 0 2.6400010 -1.26042117e-09 2.6500000 -1.26042117e-09 \
    2.6500010 9.72205504e-10 2.6600000 9.72205504e-10 2.6600010 0 2.6800000 0 \
    2.6800010 -3.77899877e-10 2.6900000 -3.77899877e-10 2.6900010 0 2.7000000 0 \
    2.7000010 -3.24115102e-10 2.7100000 -3.24115102e-10 2.7100010 1.38843233e-09 2.7200000 1.38843233e-09 \
    2.7200010 0 2.7700000 0 2.7700010 6.88408e-10 2.7800000 6.88408e-10 \
    2.7800010 6.69803816e-10 2.7900000 6.69803816e-10 2.7900010 0 2.8100000 0 \
    2.8100010 1.67393464e-10 2.8200000 1.67393464e-10 2.8200010 0 2.8600000 0 \
    2.8600010 -7.87950627e-11 2.8700000 -7.87950627e-11 2.8700010 0 2.9100000 0 \
    2.9100010 4.40132829e-10 2.9200000 4.40132829e-10 2.9200010 0 2.9300000 0 \
    2.9300010 -5.87193064e-10 2.9400000 -5.87193064e-10 2.9400010 1.46090151e-09 2.9500000 1.46090151e-09 \
    2.9500010 0 2.9700000 0 2.9700010 3.13164593e-10 2.9800000 3.13164593e-10 \
    2.9800010 -8.66007196e-10 2.9900000 -8.66007196e-10 2.9900010 1.48369352e-09 3.0000000 1.48369352e-09 \
    3.0000010 0 3.0300000 0 3.0300010 -9.20891391e-10 3.0400000 -9.20891391e-10 \
    3.0400010 1.37938319e-09 3.0500000 1.37938319e-09 3.0500010 0 3.0800000 0 \
    3.0800010 -1.10725334e-09 3.0900000 -1.10725334e-09 3.0900010 0 3.1000000 0 \
    3.1000010 6.39675274e-10 3.1100000 6.39675274e-10 3.1100010 0 3.1300000 0 \
    3.1300010 -9.74418318e-10 3.1400000 -9.74418318e-10 3.1400010 1.18837718e-09 3.1500000 1.18837718e-09 \
    3.1500010 -1.29820493e-09 3.1600000 -1.29820493e-09 3.1600010 7.26454177e-10 3.1700000 7.26454177e-10 \
    3.1700010 -1.1015157e-09 3.1800000 -1.1015157e-09 3.1800010 8.65218563e-10 3.1900000 8.65218563e-10 \
    3.1900010 -3.45585556e-11 3.2000000 -3.45585556e-11 3.2000010 -9.59266526e-10 3.2100000 -9.59266526e-10 \
    3.2100010 1.13501342e-09 3.2200000 1.13501342e-09 3.2200010 0 3.2300000 0 \
    3.2300010 3.73002355e-10 3.2400000 3.73002355e-10 3.2400010 0 3.2500000 0 \
    3.2500010 -1.09596149e-09 3.2600000 -1.09596149e-09 3.2600010 1.56301215e-09 3.2700000 1.56301215e-09 \
    3.2700010 0 3.3000000 0 3.3000010 -9.11635616e-10 3.3100000 -9.11635616e-10 \
    3.3100010 3.477181e-10 3.3200000 3.477181e-10 3.3200010 1.01600506e-09 3.3300000 1.01600506e-09 \
    3.3300010 0 3.3700000 0 3.3700010 -1.22367757e-09 3.3800000 -1.22367757e-09 \
    3.3800010 7.93940841e-10 3.3900000 7.93940841e-10 3.3900010 -1.87524636e-10 3.4000000 -1.87524636e-10 \
    3.4000010 0 3.4100000 0 3.4100010 -1.16597264e-09 3.4200000 -1.16597264e-09 \
    3.4200010 9.06527134e-10 3.4300000 9.06527134e-10 3.4300010 0 3.4600000 0 \
    3.4600010 -1.18597122e-09 3.4700000 -1.18597122e-09 3.4700010 -1.16801639e-10 3.4800000 -1.16801639e-10 \
    3.4800010 5.54006385e-10 3.4900000 5.54006385e-10 3.4900010 0 3.5000000 0 \
    3.5000010 -1.16140154e-09 3.5100000 -1.16140154e-09 3.5100010 -2.71336326e-10 3.5200000 -2.71336326e-10 \
    3.5200010 0 3.5300000 0 3.5300010 1.59950601e-10 3.5400000 1.59950601e-10 \
    3.5400010 -6.31957511e-11 3.5500000 -6.31957511e-11 3.5500010 1.47764096e-09 3.5600000 1.47764096e-09 \
    3.5600010 0 3.5700000 0 3.5700010 -1.1704303e-09 3.5800000 -1.1704303e-09 \
    3.5800010 -2.11352694e-10 3.5900000 -2.11352694e-10 3.5900010 8.84913576e-10 3.6000000 8.84913576e-10 \
    3.6000010 0 3.6200000 0 3.6200010 -1.23919256e-09 3.6300000 -1.23919256e-09 \
    3.6300010 1.01351017e-09 3.6400000 1.01351017e-09 3.6400010 0 3.6700000 0 \
    3.6700010 -1.12112548e-09 3.6800000 -1.12112548e-09 3.6800010 2.39666021e-10 3.6900000 2.39666021e-10 \
    3.6900010 1.38007903e-09 3.7000000 1.38007903e-09 3.7000010 -9.84635146e-10 3.7100000 -9.84635146e-10 \
    3.7100010 1.40932118e-09 3.7200000 1.40932118e-09 3.7200010 -6.6074227e-10 3.7300000 -6.6074227e-10 \
    3.7300010 1.3438919e-09 3.7400000 1.3438919e-09 3.7400010 0 3.7700000 0 \
    3.7700010 6.69585535e-10 3.7800000 6.69585535e-10 3.7800010 -1.15959277e-09 3.7900000 -1.15959277e-09 \
    3.7900010 8.89682983e-10 3.8000000 8.89682983e-10 3.8000010 0 3.8400000 0 \
    3.8400010 -1.20995642e-09 3.8500000 -1.20995642e-09 3.8500010 1.2353895e-09 3.8600000 1.2353895e-09 \
    3.8600010 -1.0401525e-09 3.8700000 -1.0401525e-09 3.8700010 1.10645371e-09 3.8800000 1.10645371e-09 \
    3.8800010 0 3.8900000 0 3.8900010 -9.68679624e-10 3.9000000 -9.68679624e-10 \
    3.9000010 -3.02943583e-12 3.9100000 -3.02943583e-12 3.9100010 0 3.9200000 0 \
    3.9200010 1.47793168e-09 3.9300000 1.47793168e-09 3.9300010 3.63433326e-10 3.9400000 3.63433326e-10 \
    3.9400010 0 3.9700000 0 3.9700010 -1.23340229e-09 3.9800000 -1.23340229e-09 \
    3.9800010 7.58519492e-10 3.9900000 7.58519492e-10 3.9900010 3.0891641e-10 4.0000000 3.0891641e-10 \
    4.0000010 0 4.0600000 0 ]
Rsh0 (n_ig0 0) resistor r=1G

X1 (n_in 0 n_ig1 n_rm1) ecfet_v3 Rinit=1642.09131525 A_stdp=0
ig1 (0 n_ig1) isource type=pwl wave=[ 0.0000000 0 0.0200000 0 0.0200010 -1.19622899e-09 0.0300000 -1.19622899e-09 \
    0.0300010 -1.58502527e-10 0.0400000 -1.58502527e-10 0.0400010 1.24728072e-09 0.0500000 1.24728072e-09 \
    0.0500010 0 0.0900000 0 0.0900010 -6.57954571e-10 0.1000000 -6.57954571e-10 \
    0.1000010 0 0.1100000 0 0.1100010 1.13819534e-09 0.1200000 1.13819534e-09 \
    0.1200010 4.81366253e-10 0.1300000 4.81366253e-10 0.1300010 6.14965512e-10 0.1400000 6.14965512e-10 \
    0.1400010 0 0.1800000 0 0.1800010 7.30613668e-10 0.1900000 7.30613668e-10 \
    0.1900010 0 0.2100000 0 0.2100010 4.06635307e-10 0.2200000 4.06635307e-10 \
    0.2200010 0 0.2600000 0 0.2600010 -1.18976936e-09 0.2700000 -1.18976936e-09 \
    0.2700010 8.0091889e-10 0.2800000 8.0091889e-10 0.2800010 -1.47896307e-10 0.2900000 -1.47896307e-10 \
    0.2900010 0 0.3100000 0 0.3100010 4.15962359e-10 0.3200000 4.15962359e-10 \
    0.3200010 0 0.3300000 0 0.3300010 -1.09010584e-09 0.3400000 -1.09010584e-09 \
    0.3400010 1.12944443e-09 0.3500000 1.12944443e-09 0.3500010 0 0.3700000 0 \
    0.3700010 -9.2485287e-10 0.3800000 -9.2485287e-10 0.3800010 1.28852989e-09 0.3900000 1.28852989e-09 \
    0.3900010 0 0.4100000 0 0.4100010 -8.68690932e-10 0.4200000 -8.68690932e-10 \
    0.4200010 1.08496782e-09 0.4300000 1.08496782e-09 0.4300010 0 0.4500000 0 \
    0.4500010 4.99435621e-10 0.4600000 4.99435621e-10 0.4600010 -1.04317126e-09 0.4700000 -1.04317126e-09 \
    0.4700010 -5.50280423e-10 0.4800000 -5.50280423e-10 0.4800010 0 0.4900000 0 \
    0.4900010 5.11982427e-10 0.5000000 5.11982427e-10 0.5000010 5.43127425e-10 0.5100000 5.43127425e-10 \
    0.5100010 -1.04811549e-09 0.5200000 -1.04811549e-09 0.5200010 1.07676052e-09 0.5300000 1.07676052e-09 \
    0.5300010 -1.29557675e-09 0.5400000 -1.29557675e-09 0.5400010 0 0.5500000 0 \
    0.5500010 1.32134797e-09 0.5600000 1.32134797e-09 0.5600010 0 0.5700000 0 \
    0.5700010 -5.87486675e-10 0.5800000 -5.87486675e-10 0.5800010 1.41664166e-09 0.5900000 1.41664166e-09 \
    0.5900010 0 0.6100000 0 0.6100010 -1.23874431e-09 0.6200000 -1.23874431e-09 \
    0.6200010 6.9184773e-10 0.6300000 6.9184773e-10 0.6300010 0 0.6600000 0 \
    0.6600010 -8.39083128e-10 0.6700000 -8.39083128e-10 0.6700010 6.84785302e-10 0.6800000 6.84785302e-10 \
    0.6800010 0 0.7100000 0 0.7100010 5.84015947e-10 0.7200000 5.84015947e-10 \
    0.7200010 0 0.7800000 0 0.7800010 -1.22858735e-09 0.7900000 -1.22858735e-09 \
    0.7900010 6.66679804e-10 0.8000000 6.66679804e-10 0.8000010 0 0.8200000 0 \
    0.8200010 3.76982698e-10 0.8300000 3.76982698e-10 0.8300010 0 0.8500000 0 \
    0.8500010 -1.10220679e-09 0.8600000 -1.10220679e-09 0.8600010 0 0.8700000 0 \
    0.8700010 8.46095269e-10 0.8800000 8.46095269e-10 0.8800010 0 0.8900000 0 \
    0.8900010 -1.99416099e-10 0.9000000 -1.99416099e-10 0.9000010 -1.0669226e-09 0.9100000 -1.0669226e-09 \
    0.9100010 1.01457755e-09 0.9200000 1.01457755e-09 0.9200010 -1.17800648e-09 0.9300000 -1.17800648e-09 \
    0.9300010 1.02441917e-09 0.9400000 1.02441917e-09 0.9400010 -1.1669898e-09 0.9500000 -1.1669898e-09 \
    0.9500010 9.37846309e-10 0.9600000 9.37846309e-10 0.9600010 0 0.9800000 0 \
    0.9800010 3.81824283e-10 0.9900000 3.81824283e-10 0.9900010 0 1.0200000 0 \
    1.0200010 -1.22347728e-09 1.0300000 -1.22347728e-09 1.0300010 9.25719211e-10 1.0400000 9.25719211e-10 \
    1.0400010 0 1.0600000 0 1.0600010 -1.08878911e-09 1.0700000 -1.08878911e-09 \
    1.0700010 1.12370721e-09 1.0800000 1.12370721e-09 1.0800010 0 1.0900000 0 \
    1.0900010 2.36913326e-10 1.1000000 2.36913326e-10 1.1000010 0 1.1400000 0 \
    1.1400010 -1.25050647e-09 1.1500000 -1.25050647e-09 1.1500010 8.46107883e-10 1.1600000 8.46107883e-10 \
    1.1600010 0 1.1700000 0 1.1700010 -1.23252567e-09 1.1800000 -1.23252567e-09 \
    1.1800010 0 1.1900000 0 1.1900010 7.28602295e-10 1.2000000 7.28602295e-10 \
    1.2000010 0 1.2100000 0 1.2100010 1.77862181e-10 1.2200000 1.77862181e-10 \
    1.2200010 -9.65795362e-10 1.2300000 -9.65795362e-10 1.2300010 8.36416489e-10 1.2400000 8.36416489e-10 \
    1.2400010 0 1.2500000 0 1.2500010 -1.21874683e-09 1.2600000 -1.21874683e-09 \
    1.2600010 9.34367705e-10 1.2700000 9.34367705e-10 1.2700010 -7.0421434e-10 1.2800000 -7.0421434e-10 \
    1.2800010 0 1.2900000 0 1.2900010 -6.80523998e-10 1.3000000 -6.80523998e-10 \
    1.3000010 1.45525096e-09 1.3100000 1.45525096e-09 1.3100010 0 1.3200000 0 \
    1.3200010 -1.19303153e-09 1.3300000 -1.19303153e-09 1.3300010 0 1.3400000 0 \
    1.3400010 -7.76749525e-10 1.3500000 -7.76749525e-10 1.3500010 0 1.3600000 0 \
    1.3600010 7.34287304e-10 1.3700000 7.34287304e-10 1.3700010 -1.27542431e-09 1.3800000 -1.27542431e-09 \
    1.3800010 0 1.3900000 0 1.3900010 7.09218836e-10 1.4000000 7.09218836e-10 \
    1.4000010 0 1.4100000 0 1.4100010 2.8502697e-10 1.4200000 2.8502697e-10 \
    1.4200010 0 1.4400000 0 1.4400010 -1.28094548e-09 1.4500000 -1.28094548e-09 \
    1.4500010 -1.37682921e-10 1.4600000 -1.37682921e-10 1.4600010 0 1.4700000 0 \
    1.4700010 1.41098307e-09 1.4800000 1.41098307e-09 1.4800010 0 1.5000000 0 \
    1.5000010 -1.2231152e-09 1.5100000 -1.2231152e-09 1.5100010 1.01432502e-09 1.5200000 1.01432502e-09 \
    1.5200010 0 1.5500000 0 1.5500010 3.9141069e-10 1.5600000 3.9141069e-10 \
    1.5600010 0 1.5700000 0 1.5700010 -9.75645918e-10 1.5800000 -9.75645918e-10 \
    1.5800010 1.13700366e-09 1.5900000 1.13700366e-09 1.5900010 0 1.6000000 0 \
    1.6000010 4.37266537e-10 1.6100000 4.37266537e-10 1.6100010 2.17068624e-10 1.6200000 2.17068624e-10 \
    1.6200010 0 1.6500000 0 1.6500010 -9.4793934e-10 1.6600000 -9.4793934e-10 \
    1.6600010 9.89810055e-10 1.6700000 9.89810055e-10 1.6700010 -8.47326885e-10 1.6800000 -8.47326885e-10 \
    1.6800010 9.20548616e-10 1.6900000 9.20548616e-10 1.6900010 -8.92667468e-10 1.7000000 -8.92667468e-10 \
    1.7000010 1.4535898e-09 1.7100000 1.4535898e-09 1.7100010 0 1.7200000 0 \
    1.7200010 7.61493483e-10 1.7300000 7.61493483e-10 1.7300010 -1.09455435e-09 1.7400000 -1.09455435e-09 \
    1.7400010 -2.39766332e-10 1.7500000 -2.39766332e-10 1.7500010 2.34251252e-10 1.7600000 2.34251252e-10 \
    1.7600010 1.43982721e-09 1.7700000 1.43982721e-09 1.7700010 -1.1141954e-09 1.7800000 -1.1141954e-09 \
    1.7800010 1.02911226e-09 1.7900000 1.02911226e-09 1.7900010 0 1.8100000 0 \
    1.8100010 5.66173062e-10 1.8200000 5.66173062e-10 1.8200010 -1.25856431e-09 1.8300000 -1.25856431e-09 \
    1.8300010 -1.29582966e-10 1.8400000 -1.29582966e-10 1.8400010 0 1.8500000 0 \
    1.8500010 8.53253641e-10 1.8600000 8.53253641e-10 1.8600010 0 1.8800000 0 \
    1.8800010 -9.43252936e-10 1.8900000 -9.43252936e-10 1.8900010 2.95369988e-10 1.9000000 2.95369988e-10 \
    1.9000010 3.21530246e-10 1.9100000 3.21530246e-10 1.9100010 0 1.9200000 0 \
    1.9200010 5.93872418e-10 1.9300000 5.93872418e-10 1.9300010 0 1.9500000 0 \
    1.9500010 -1.12538853e-09 1.9600000 -1.12538853e-09 1.9600010 0 1.9700000 0 \
    1.9700010 -3.37064219e-10 1.9800000 -3.37064219e-10 1.9800010 1.02983154e-09 1.9900000 1.02983154e-09 \
    1.9900010 0 2.0500000 0 2.0500010 -1.24351492e-09 2.0600000 -1.24351492e-09 \
    2.0600010 9.81221598e-10 2.0700000 9.81221598e-10 2.0700010 0 2.1000000 0 \
    2.1000010 -9.8127373e-10 2.1100000 -9.8127373e-10 2.1100010 1.25107303e-09 2.1200000 1.25107303e-09 \
    2.1200010 0 2.1500000 0 2.1500010 8.05635808e-10 2.1600000 8.05635808e-10 \
    2.1600010 0 2.1800000 0 2.1800010 9.4322631e-12 2.1900000 9.4322631e-12 \
    2.1900010 0 2.2100000 0 2.2100010 -1.05514855e-09 2.2200000 -1.05514855e-09 \
    2.2200010 8.83901718e-10 2.2300000 8.83901718e-10 2.2300010 0 2.2500000 0 \
    2.2500010 4.94536519e-10 2.2600000 4.94536519e-10 2.2600010 -1.21726535e-09 2.2700000 -1.21726535e-09 \
    2.2700010 1.47904656e-09 2.2800000 1.47904656e-09 2.2800010 2.34812283e-10 2.2900000 2.34812283e-10 \
    2.2900010 -9.48382019e-10 2.3000000 -9.48382019e-10 2.3000010 9.88883489e-10 2.3100000 9.88883489e-10 \
    2.3100010 0 2.3400000 0 2.3400010 -1.08280344e-09 2.3500000 -1.08280344e-09 \
    2.3500010 1.29640277e-09 2.3600000 1.29640277e-09 2.3600010 0 2.3700000 0 \
    2.3700010 -1.20303879e-09 2.3800000 -1.20303879e-09 2.3800010 8.36300022e-10 2.3900000 8.36300022e-10 \
    2.3900010 0 2.4000000 0 2.4000010 -1.28681254e-09 2.4100000 -1.28681254e-09 \
    2.4100010 0 2.4200000 0 2.4200010 1.14308135e-09 2.4300000 1.14308135e-09 \
    2.4300010 0 2.4400000 0 2.4400010 -8.22929797e-10 2.4500000 -8.22929797e-10 \
    2.4500010 -2.62021689e-10 2.4600000 -2.62021689e-10 2.4600010 1.10743815e-09 2.4700000 1.10743815e-09 \
    2.4700010 0 2.4800000 0 2.4800010 6.81804167e-10 2.4900000 6.81804167e-10 \
    2.4900010 -1.22937418e-09 2.5000000 -1.22937418e-09 2.5000010 -1.9434468e-10 2.5100000 -1.9434468e-10 \
    2.5100010 9.42829896e-10 2.5200000 9.42829896e-10 2.5200010 0 2.5300000 0 \
    2.5300010 -1.18002712e-09 2.5400000 -1.18002712e-09 2.5400010 1.33723457e-09 2.5500000 1.33723457e-09 \
    2.5500010 3.35577236e-11 2.5600000 3.35577236e-11 2.5600010 0 2.5800000 0 \
    2.5800010 -1.06233062e-10 2.5900000 -1.06233062e-10 2.5900010 0 2.6100000 0 \
    2.6100010 -1.03687311e-09 2.6200000 -1.03687311e-09 2.6200010 -4.30207958e-10 2.6300000 -4.30207958e-10 \
    2.6300010 0 2.6400000 0 2.6400010 5.91567327e-10 2.6500000 5.91567327e-10 \
    2.6500010 -1.02073069e-09 2.6600000 -1.02073069e-09 2.6600010 9.16474504e-10 2.6700000 9.16474504e-10 \
    2.6700010 0 2.7000000 0 2.7000010 -1.09522272e-09 2.7100000 -1.09522272e-09 \
    2.7100010 1.17861359e-09 2.7200000 1.17861359e-09 2.7200010 5.16294393e-10 2.7300000 5.16294393e-10 \
    2.7300010 0 2.7400000 0 2.7400010 6.72707514e-10 2.7500000 6.72707514e-10 \
    2.7500010 0 2.7800000 0 2.7800010 -1.84764009e-10 2.7900000 -1.84764009e-10 \
    2.7900010 0 2.8100000 0 2.8100010 -9.50565119e-10 2.8200000 -9.50565119e-10 \
    2.8200010 1.12598384e-09 2.8300000 1.12598384e-09 2.8300010 -9.93192725e-10 2.8400000 -9.93192725e-10 \
    2.8400010 2.80504868e-10 2.8500000 2.80504868e-10 2.8500010 1.1638962e-09 2.8600000 1.1638962e-09 \
    2.8600010 0 2.8900000 0 2.8900010 -1.21763859e-09 2.9000000 -1.21763859e-09 \
    2.9000010 0 2.9100000 0 2.9100010 -6.08573654e-10 2.9200000 -6.08573654e-10 \
    2.9200010 0 2.9400000 0 2.9400010 7.1213132e-10 2.9500000 7.1213132e-10 \
    2.9500010 -1.24118579e-09 2.9600000 -1.24118579e-09 2.9600010 8.28767784e-10 2.9700000 8.28767784e-10 \
    2.9700010 -1.19480237e-09 2.9800000 -1.19480237e-09 2.9800010 0 2.9900000 0 \
    2.9900010 7.35029737e-10 3.0000000 7.35029737e-10 3.0000010 0 3.0100000 0 \
    3.0100010 -1.22729549e-09 3.0200000 -1.22729549e-09 3.0200010 1.10507775e-09 3.0300000 1.10507775e-09 \
    3.0300010 -9.35117881e-10 3.0400000 -9.35117881e-10 3.0400010 2.57428852e-10 3.0500000 2.57428852e-10 \
    3.0500010 1.24073568e-09 3.0600000 1.24073568e-09 3.0600010 -4.38588255e-11 3.0700000 -4.38588255e-11 \
    3.0700010 0 3.0800000 0 3.0800010 -9.81780403e-10 3.0900000 -9.81780403e-10 \
    3.0900010 0 3.1000000 0 3.1000010 6.22841971e-10 3.1100000 6.22841971e-10 \
    3.1100010 4.26682878e-10 3.1200000 4.26682878e-10 3.1200010 1.72297863e-10 3.1300000 1.72297863e-10 \
    3.1300010 -1.02799366e-09 3.1400000 -1.02799366e-09 3.1400010 1.06739693e-09 3.1500000 1.06739693e-09 \
    3.1500010 2.71296297e-10 3.1600000 2.71296297e-10 3.1600010 0 3.1700000 0 \
    3.1700010 -9.47979522e-10 3.1800000 -9.47979522e-10 3.1800010 1.15868116e-10 3.1900000 1.15868116e-10 \
    3.1900010 8.84988612e-10 3.2000000 8.84988612e-10 3.2000010 0 3.2100000 0 \
    3.2100010 -4.8250503e-10 3.2200000 -4.8250503e-10 3.2200010 1.31902687e-09 3.2300000 1.31902687e-09 \
    3.2300010 -1.18291837e-09 3.2400000 -1.18291837e-09 3.2400010 7.58898197e-10 3.2500000 7.58898197e-10 \
    3.2500010 -1.10237476e-09 3.2600000 -1.10237476e-09 3.2600010 1.16833818e-09 3.2700000 1.16833818e-09 \
    3.2700010 0 3.2800000 0 3.2800010 -9.23607739e-10 3.2900000 -9.23607739e-10 \
    3.2900010 1.00025204e-09 3.3000000 1.00025204e-09 3.3000010 0 3.3100000 0 \
    3.3100010 -1.37996357e-09 3.3200000 -1.37996357e-09 3.3200010 1.21638801e-09 3.3300000 1.21638801e-09 \
    3.3300010 0 3.3400000 0 3.3400010 -1.24191284e-09 3.3500000 -1.24191284e-09 \
    3.3500010 1.29321699e-09 3.3600000 1.29321699e-09 3.3600010 0 3.3700000 0 \
    3.3700010 -1.14529163e-09 3.3800000 -1.14529163e-09 3.3800010 1.25896623e-09 3.3900000 1.25896623e-09 \
    3.3900010 0 3.4100000 0 3.4100010 -1.26155148e-09 3.4200000 -1.26155148e-09 \
    3.4200010 7.7400525e-10 3.4300000 7.7400525e-10 3.4300010 0 3.4600000 0 \
    3.4600010 -1.27567811e-09 3.4700000 -1.27567811e-09 3.4700010 9.77690901e-10 3.4800000 9.77690901e-10 \
    3.4800010 0 3.5100000 0 3.5100010 5.12760229e-10 3.5200000 5.12760229e-10 \
    3.5200010 0 3.5800000 0 3.5800010 3.28170209e-10 3.5900000 3.28170209e-10 \
    3.5900010 -6.07299404e-11 3.6000000 -6.07299404e-11 3.6000010 0 3.6100000 0 \
    3.6100010 -1.00369553e-09 3.6200000 -1.00369553e-09 3.6200010 9.25639577e-10 3.6300000 9.25639577e-10 \
    3.6300010 0 3.6600000 0 3.6600010 -8.64007389e-10 3.6700000 -8.64007389e-10 \
    3.6700010 9.85360037e-10 3.6800000 9.85360037e-10 3.6800010 0 3.6900000 0 \
    3.6900010 -1.20300775e-09 3.7000000 -1.20300775e-09 3.7000010 0 3.7100000 0 \
    3.7100010 -6.22573363e-10 3.7200000 -6.22573363e-10 3.7200010 1.04940146e-11 3.7300000 1.04940146e-11 \
    3.7300010 8.81592454e-10 3.7400000 8.81592454e-10 3.7400010 6.38162781e-10 3.7500000 6.38162781e-10 \
    3.7500010 0 3.7800000 0 3.7800010 5.92435424e-11 3.7900000 5.92435424e-11 \
    3.7900010 0 3.8100000 0 3.8100010 -1.22197592e-09 3.8200000 -1.22197592e-09 \
    3.8200010 -4.23576554e-10 3.8300000 -4.23576554e-10 3.8300010 0 3.8400000 0 \
    3.8400010 7.89338318e-10 3.8500000 7.89338318e-10 3.8500010 -1.20485244e-09 3.8600000 -1.20485244e-09 \
    3.8600010 0 3.8700000 0 3.8700010 -1.29003137e-10 3.8800000 -1.29003137e-10 \
    3.8800010 1.15416434e-09 3.8900000 1.15416434e-09 3.8900010 0 3.9200000 0 \
    3.9200010 -1.03190627e-09 3.9300000 -1.03190627e-09 3.9300010 1.10436364e-09 3.9400000 1.10436364e-09 \
    3.9400010 0 3.9700000 0 3.9700010 -1.02097423e-09 3.9800000 -1.02097423e-09 \
    3.9800010 1.10824382e-09 3.9900000 1.10824382e-09 3.9900010 0 4.0600000 0 ]
Rsh1 (n_ig1 0) resistor r=1G

X2 (n_in 0 n_ig2 n_rm2) ecfet_v3 Rinit=1642.09131525 A_stdp=0
ig2 (0 n_ig2) isource type=pwl wave=[ 0.0000000 0 0.0200000 0 0.0200010 -9.27197876e-10 0.0300000 -9.27197876e-10 \
    0.0300010 1.41851802e-09 0.0400000 1.41851802e-09 0.0400010 0 0.0700000 0 \
    0.0700010 -7.94601131e-10 0.0800000 -7.94601131e-10 0.0800010 1.44414593e-09 0.0900000 1.44414593e-09 \
    0.0900010 0 0.1200000 0 0.1200010 -1.05342089e-09 0.1300000 -1.05342089e-09 \
    0.1300010 8.84872963e-10 0.1400000 8.84872963e-10 0.1400010 0 0.1600000 0 \
    0.1600010 -9.31943886e-10 0.1700000 -9.31943886e-10 0.1700010 0 0.1800000 0 \
    0.1800010 4.52918266e-10 0.1900000 4.52918266e-10 0.1900010 1.40569281e-09 0.2000000 1.40569281e-09 \
    0.2000010 -1.19708445e-09 0.2100000 -1.19708445e-09 0.2100010 6.0163723e-10 0.2200000 6.0163723e-10 \
    0.2200010 -9.12219428e-10 0.2300000 -9.12219428e-10 0.2300010 1.43968647e-09 0.2400000 1.43968647e-09 \
    0.2400010 0 0.2700000 0 0.2700010 -1.13027674e-09 0.2800000 -1.13027674e-09 \
    0.2800010 8.31459639e-10 0.2900000 8.31459639e-10 0.2900010 0 0.3000000 0 \
    0.3000010 2.03988561e-10 0.3100000 2.03988561e-10 0.3100010 1.16223707e-10 0.3200000 1.16223707e-10 \
    0.3200010 0 0.3300000 0 0.3300010 -6.60363663e-10 0.3400000 -6.60363663e-10 \
    0.3400010 9.61684438e-10 0.3500000 9.61684438e-10 0.3500010 0 0.3600000 0 \
    0.3600010 -1.28690454e-09 0.3700000 -1.28690454e-09 0.3700010 0 0.3800000 0 \
    0.3800010 4.31491037e-10 0.3900000 4.31491037e-10 0.3900010 0 0.4000000 0 \
    0.4000010 -6.24757407e-12 0.4100000 -6.24757407e-12 0.4100010 0 0.4200000 0 \
    0.4200010 1.63081392e-10 0.4300000 1.63081392e-10 0.4300010 0 0.4400000 0 \
    0.4400010 4.63958872e-11 0.4500000 4.63958872e-11 0.4500010 6.40133307e-10 0.4600000 6.40133307e-10 \
    0.4600010 0 0.4800000 0 0.4800010 -9.88049789e-10 0.4900000 -9.88049789e-10 \
    0.4900010 8.38024963e-10 0.5000000 8.38024963e-10 0.5000010 0 0.5300000 0 \
    0.5300010 6.88288697e-10 0.5400000 6.88288697e-10 0.5400010 0 0.5500000 0 \
    0.5500010 6.41232669e-10 0.5600000 6.41232669e-10 0.5600010 -8.42520936e-10 0.5700000 -8.42520936e-10 \
    0.5700010 0 0.5800000 0 0.5800010 4.75840747e-10 0.5900000 4.75840747e-10 \
    0.5900010 0 0.6000000 0 0.6000010 2.99374184e-10 0.6100000 2.99374184e-10 \
    0.6100010 -4.04288782e-10 0.6200000 -4.04288782e-10 0.6200010 9.56110708e-10 0.6300000 9.56110708e-10 \
    0.6300010 -1.04433824e-09 0.6400000 -1.04433824e-09 0.6400010 6.42357478e-10 0.6500000 6.42357478e-10 \
    0.6500010 0 0.6600000 0 0.6600010 -7.29984299e-10 0.6700000 -7.29984299e-10 \
    0.6700010 2.07817322e-10 0.6800000 2.07817322e-10 0.6800010 0 0.6900000 0 \
    0.6900010 -6.26341851e-10 0.7000000 -6.26341851e-10 0.7000010 0 0.7100000 0 \
    0.7100010 5.05909942e-10 0.7200000 5.05909942e-10 0.7200010 -9.31574438e-10 0.7300000 -9.31574438e-10 \
    0.7300010 0 0.7400000 0 0.7400010 7.00289041e-10 0.7500000 7.00289041e-10 \
    0.7500010 0 0.7600000 0 0.7600010 -5.64556534e-10 0.7700000 -5.64556534e-10 \
    0.7700010 1.48841263e-09 0.7800000 1.48841263e-09 0.7800010 -1.26539984e-09 0.7900000 -1.26539984e-09 \
    0.7900010 -2.00444429e-10 0.8000000 -2.00444429e-10 0.8000010 0 0.8100000 0 \
    0.8100010 7.82326866e-10 0.8200000 7.82326866e-10 0.8200010 -1.27219949e-09 0.8300000 -1.27219949e-09 \
    0.8300010 0 0.8400000 0 0.8400010 5.29336014e-10 0.8500000 5.29336014e-10 \
    0.8500010 0 0.8700000 0 0.8700010 -1.051826e-09 0.8800000 -1.051826e-09 \
    0.8800010 8.73267958e-10 0.8900000 8.73267958e-10 0.8900010 0 0.9200000 0 \
    0.9200010 -1.19741209e-09 0.9300000 -1.19741209e-09 0.9300010 9.91387729e-10 0.9400000 9.91387729e-10 \
    0.9400010 -1.23129842e-09 0.9500000 -1.23129842e-09 0.9500010 8.42171388e-10 0.9600000 8.42171388e-10 \
    0.9600010 -9.48919416e-10 0.9700000 -9.48919416e-10 0.9700010 2.12987747e-10 0.9800000 2.12987747e-10 \
    0.9800010 3.5920143e-10 0.9900000 3.5920143e-10 0.9900010 1.00059321e-10 1.0000000 1.00059321e-10 \
    1.0000010 1.36713906e-09 1.0100000 1.36713906e-09 1.0100010 0 1.0200000 0 \
    1.0200010 -9.47165988e-10 1.0300000 -9.47165988e-10 1.0300010 3.04921201e-10 1.0400000 3.04921201e-10 \
    1.0400010 1.01649533e-09 1.0500000 1.01649533e-09 1.0500010 -9.96536744e-10 1.0600000 -9.96536744e-10 \
    1.0600010 -1.88969583e-10 1.0700000 -1.88969583e-10 1.0700010 9.52777608e-10 1.0800000 9.52777608e-10 \
    1.0800010 0 1.1100000 0 1.1100010 5.68540002e-10 1.1200000 5.68540002e-10 \
    1.1200010 0 1.1400000 0 1.1400010 5.65881681e-10 1.1500000 5.65881681e-10 \
    1.1500010 0 1.1600000 0 1.1600010 -8.63555022e-10 1.1700000 -8.63555022e-10 \
    1.1700010 -1.93434296e-10 1.1800000 -1.93434296e-10 1.1800010 0 1.1900000 0 \
    1.1900010 2.23382457e-10 1.2000000 2.23382457e-10 1.2000010 1.40450056e-09 1.2100000 1.40450056e-09 \
    1.2100010 4.53802436e-10 1.2200000 4.53802436e-10 1.2200010 -9.06636104e-10 1.2300000 -9.06636104e-10 \
    1.2300010 -1.80170056e-10 1.2400000 -1.80170056e-10 1.2400010 0 1.2500000 0 \
    1.2500010 5.51094942e-10 1.2600000 5.51094942e-10 1.2600010 0 1.2700000 0 \
    1.2700010 3.17514728e-10 1.2800000 3.17514728e-10 1.2800010 0 1.3000000 0 \
    1.3000010 -7.14526097e-10 1.3100000 -7.14526097e-10 1.3100010 0 1.3200000 0 \
    1.3200010 1.45766068e-09 1.3300000 1.45766068e-09 1.3300010 0 1.3500000 0 \
    1.3500010 -9.14220359e-10 1.3600000 -9.14220359e-10 1.3600010 4.51174985e-10 1.3700000 4.51174985e-10 \
    1.3700010 1.41616016e-09 1.3800000 1.41616016e-09 1.3800010 -1.22891809e-09 1.3900000 -1.22891809e-09 \
    1.3900010 2.30196594e-10 1.4000000 2.30196594e-10 1.4000010 1.29978649e-09 1.4100000 1.29978649e-09 \
    1.4100010 1.3095314e-10 1.4200000 1.3095314e-10 1.4200010 -9.97972048e-10 1.4300000 -9.97972048e-10 \
    1.4300010 -2.87279733e-10 1.4400000 -2.87279733e-10 1.4400010 9.43386462e-10 1.4500000 9.43386462e-10 \
    1.4500010 0 1.4800000 0 1.4800010 -1.13461364e-09 1.4900000 -1.13461364e-09 \
    1.4900010 0 1.5000000 0 1.5000010 6.20041438e-10 1.5100000 6.20041438e-10 \
    1.5100010 -1.00707386e-09 1.5200000 -1.00707386e-09 1.5200010 1.09265249e-09 1.5300000 1.09265249e-09 \
    1.5300010 0 1.5600000 0 1.5600010 4.71496549e-10 1.5700000 4.71496549e-10 \
    1.5700010 -1.1461696e-09 1.5800000 -1.1461696e-09 1.5800010 4.04243309e-10 1.5900000 4.04243309e-10 \
    1.5900010 -3.00423827e-10 1.6000000 -3.00423827e-10 1.6000010 1.0632792e-09 1.6100000 1.0632792e-09 \
    1.6100010 -9.6798141e-10 1.6200000 -9.6798141e-10 1.6200010 0 1.6300000 0 \
    1.6300010 1.25418559e-09 1.6400000 1.25418559e-09 1.6400010 0 1.6600000 0 \
    1.6600010 -1.26470303e-09 1.6700000 -1.26470303e-09 1.6700010 0 1.6800000 0 \
    1.6800010 6.24200313e-10 1.6900000 6.24200313e-10 1.6900010 0 1.7100000 0 \
    1.7100010 -8.46005264e-10 1.7200000 -8.46005264e-10 1.7200010 1.0401796e-09 1.7300000 1.0401796e-09 \
    1.7300010 0 1.7400000 0 1.7400010 -1.06368347e-09 1.7500000 -1.06368347e-09 \
    1.7500010 7.90269854e-10 1.7600000 7.90269854e-10 1.7600010 0 1.7700000 0 \
    1.7700010 3.6233167e-10 1.7800000 3.6233167e-10 1.7800010 -1.1878046e-09 1.7900000 -1.1878046e-09 \
    1.7900010 0 1.8000000 0 1.8000010 1.38722226e-09 1.8100000 1.38722226e-09 \
    1.8100010 7.1720879e-10 1.8200000 7.1720879e-10 1.8200010 3.10320589e-11 1.8300000 3.10320589e-11 \
    1.8300010 2.74454275e-10 1.8400000 2.74454275e-10 1.8400010 -1.03525499e-09 1.8500000 -1.03525499e-09 \
    1.8500010 -1.73504123e-10 1.8600000 -1.73504123e-10 1.8600010 -2.79636319e-11 1.8700000 -2.79636319e-11 \
    1.8700010 1.05733125e-09 1.8800000 1.05733125e-09 1.8800010 0 1.8900000 0 \
    1.8900010 -1.25025913e-09 1.9000000 -1.25025913e-09 1.9000010 8.51497062e-10 1.9100000 8.51497062e-10 \
    1.9100010 0 1.9400000 0 1.9400010 -1.11522825e-09 1.9500000 -1.11522825e-09 \
    1.9500010 8.49049073e-10 1.9600000 8.49049073e-10 1.9600010 -8.11569035e-10 1.9700000 -8.11569035e-10 \
    1.9700010 1.4887075e-09 1.9800000 1.4887075e-09 1.9800010 -6.70023542e-10 1.9900000 -6.70023542e-10 \
    1.9900010 -1.20753119e-10 2.0000000 -1.20753119e-10 2.0000010 1.16645171e-09 2.0100000 1.16645171e-09 \
    2.0100010 0 2.0400000 0 2.0400010 7.73425734e-10 2.0500000 7.73425734e-10 \
    2.0500010 -8.85389594e-10 2.0600000 -8.85389594e-10 2.0600010 9.18885015e-10 2.0700000 9.18885015e-10 \
    2.0700010 0 2.0900000 0 2.0900010 8.41974457e-10 2.1000000 8.41974457e-10 \
    2.1000010 -1.15691555e-09 2.1100000 -1.15691555e-09 2.1100010 8.99153891e-10 2.1200000 8.99153891e-10 \
    2.1200010 0 2.1300000 0 2.1300010 -1.14029922e-09 2.1400000 -1.14029922e-09 \
    2.1400010 0 2.1500000 0 2.1500010 6.04331772e-10 2.1600000 6.04331772e-10 \
    2.1600010 -9.77955958e-10 2.1700000 -9.77955958e-10 2.1700010 1.33870858e-09 2.1800000 1.33870858e-09 \
    2.1800010 -1.00957536e-09 2.1900000 -1.00957536e-09 2.1900010 1.46195377e-09 2.2000000 1.46195377e-09 \
    2.2000010 -1.54227752e-10 2.2100000 -1.54227752e-10 2.2100010 0 2.2200000 0 \
    2.2200010 7.12043093e-10 2.2300000 7.12043093e-10 2.2300010 0 2.2700000 0 \
    2.2700010 -1.17001687e-09 2.2800000 -1.17001687e-09 2.2800010 7.22297552e-10 2.2900000 7.22297552e-10 \
    2.2900010 -9.12141743e-10 2.3000000 -9.12141743e-10 2.3000010 1.06927104e-09 2.3100000 1.06927104e-09 \
    2.3100010 0 2.3200000 0 2.3200010 -1.23377383e-09 2.3300000 -1.23377383e-09 \
    2.3300010 0 2.3400000 0 2.3400010 5.66285101e-10 2.3500000 5.66285101e-10 \
    2.3500010 -1.1049273e-09 2.3600000 -1.1049273e-09 2.3600010 -4.62135811e-11 2.3700000 -4.62135811e-11 \
    2.3700010 4.61049134e-11 2.3800000 4.61049134e-11 2.3800010 1.42648567e-09 2.3900000 1.42648567e-09 \
    2.3900010 -8.93701084e-10 2.4000000 -8.93701084e-10 2.4000010 1.13964435e-09 2.4100000 1.13964435e-09 \
    2.4100010 -1.12321059e-09 2.4200000 -1.12321059e-09 2.4200010 4.85413432e-10 2.4300000 4.85413432e-10 \
    2.4300010 1.61145011e-10 2.4400000 1.61145011e-10 2.4400010 5.65057344e-11 2.4500000 5.65057344e-11 \
    2.4500010 1.0192908e-09 2.4600000 1.0192908e-09 2.4600010 -8.14605957e-10 2.4700000 -8.14605957e-10 \
    2.4700010 0 2.4800000 0 2.4800010 3.67029576e-10 2.4900000 3.67029576e-10 \
    2.4900010 -2.24865236e-10 2.5000000 -2.24865236e-10 2.5000010 1.33526861e-09 2.5100000 1.33526861e-09 \
    2.5100010 0 2.5200000 0 2.5200010 -9.72211874e-10 2.5300000 -9.72211874e-10 \
    2.5300010 -6.35171667e-11 2.5400000 -6.35171667e-11 2.5400010 -2.0961996e-10 2.5500000 -2.0961996e-10 \
    2.5500010 -3.24939289e-10 2.5600000 -3.24939289e-10 2.5600010 0 2.5700000 0 \
    2.5700010 1.94232074e-10 2.5800000 1.94232074e-10 2.5800010 -1.16952915e-10 2.5900000 -1.16952915e-10 \
    2.5900010 1.41696354e-09 2.6000000 1.41696354e-09 2.6000010 -2.77620887e-10 2.6100000 -2.77620887e-10 \
    2.6100010 0 2.6200000 0 2.6200010 3.14242626e-10 2.6300000 3.14242626e-10 \
    2.6300010 0 2.6400000 0 2.6400010 -6.19371172e-10 2.6500000 -6.19371172e-10 \
    2.6500010 1.37757494e-09 2.6600000 1.37757494e-09 2.6600010 0 2.6700000 0 \
    2.6700010 -1.18629565e-09 2.6800000 -1.18629565e-09 2.6800010 1.51916228e-10 2.6900000 1.51916228e-10 \
    2.6900010 0 2.7000000 0 2.7000010 -2.66850509e-11 2.7100000 -2.66850509e-11 \
    2.7100010 -1.94852161e-10 2.7200000 -1.94852161e-10 2.7200010 6.86921353e-10 2.7300000 6.86921353e-10 \
    2.7300010 -1.23522265e-09 2.7400000 -1.23522265e-09 2.7400010 7.86317775e-11 2.7500000 7.86317775e-11 \
    2.7500010 1.78074871e-10 2.7600000 1.78074871e-10 2.7600010 0 2.7700000 0 \
    2.7700010 3.40075928e-10 2.7800000 3.40075928e-10 2.7800010 1.41903531e-09 2.7900000 1.41903531e-09 \
    2.7900010 -1.01098841e-09 2.8000000 -1.01098841e-09 2.8000010 1.47503112e-09 2.8100000 1.47503112e-09 \
    2.8100010 0 2.8500000 0 2.8500010 3.61037627e-10 2.8600000 3.61037627e-10 \
    2.8600010 0 2.9000000 0 2.9000010 -1.15827229e-09 2.9100000 -1.15827229e-09 \
    2.9100010 7.19722023e-10 2.9200000 7.19722023e-10 2.9200010 0 2.9500000 0 \
    2.9500010 3.74245391e-10 2.9600000 3.74245391e-10 2.9600010 -1.18246736e-09 2.9700000 -1.18246736e-09 \
    2.9700010 -8.33551188e-11 2.9800000 -8.33551188e-11 2.9800010 0 2.9900000 0 \
    2.9900010 2.70487941e-10 3.0000000 2.70487941e-10 3.0000010 1.4281664e-09 3.0100000 1.4281664e-09 \
    3.0100010 0 3.0500000 0 3.0500010 3.01083429e-10 3.0600000 3.01083429e-10 \
    3.0600010 0 3.0700000 0 3.0700010 -1.10991409e-09 3.0800000 -1.10991409e-09 \
    3.0800010 1.05577641e-09 3.0900000 1.05577641e-09 3.0900010 0 3.1000000 0 \
    3.1000010 5.28705577e-10 3.1100000 5.28705577e-10 3.1100010 -1.16380136e-09 3.1200000 -1.16380136e-09 \
    3.1200010 7.88792115e-10 3.1300000 7.88792115e-10 3.1300010 0 3.1400000 0 \
    3.1400010 -1.12986101e-09 3.1500000 -1.12986101e-09 3.1500010 9.31704732e-10 3.1600000 9.31704732e-10 \
    3.1600010 -7.20697252e-10 3.1700000 -7.20697252e-10 3.1700010 0 3.1800000 0 \
    3.1800010 3.3662583e-10 3.1900000 3.3662583e-10 3.1900010 1.48922862e-09 3.2000000 1.48922862e-09 \
    3.2000010 -1.21447637e-09 3.2100000 -1.21447637e-09 3.2100010 -3.43758671e-10 3.2200000 -3.43758671e-10 \
    3.2200010 1.43184597e-09 3.2300000 1.43184597e-09 3.2300010 -7.41917659e-10 3.2400000 -7.41917659e-10 \
    3.2400010 1.18791522e-09 3.2500000 1.18791522e-09 3.2500010 1.05600489e-10 3.2600000 1.05600489e-10 \
    3.2600010 -1.25117511e-09 3.2700000 -1.25117511e-09 3.2700010 8.78853742e-10 3.2800000 8.78853742e-10 \
    3.2800010 0 3.2900000 0 3.2900010 2.68662974e-10 3.3000000 2.68662974e-10 \
    3.3000010 0 3.3100000 0 3.3100010 1.72505756e-10 3.3200000 1.72505756e-10 \
    3.3200010 -1.21500046e-09 3.3300000 -1.21500046e-09 3.3300010 -3.59425674e-11 3.3400000 -3.59425674e-11 \
    3.3400010 1.27718862e-09 3.3500000 1.27718862e-09 3.3500010 0 3.3600000 0 \
    3.3600010 -8.19227136e-10 3.3700000 -8.19227136e-10 3.3700010 1.42601936e-09 3.3800000 1.42601936e-09 \
    3.3800010 -8.24606995e-10 3.3900000 -8.24606995e-10 3.3900010 1.35695681e-09 3.4000000 1.35695681e-09 \
    3.4000010 -1.24423279e-09 3.4100000 -1.24423279e-09 3.4100010 7.19183715e-10 3.4200000 7.19183715e-10 \
    3.4200010 2.12796358e-10 3.4300000 2.12796358e-10 3.4300010 -1.11934367e-09 3.4400000 -1.11934367e-09 \
    3.4400010 1.47180574e-09 3.4500000 1.47180574e-09 3.4500010 0 3.4600000 0 \
    3.4600010 -6.17869392e-10 3.4700000 -6.17869392e-10 3.4700010 -1.92666165e-10 3.4800000 -1.92666165e-10 \
    3.4800010 9.4853165e-10 3.4900000 9.4853165e-10 3.4900010 0 3.5000000 0 \
    3.5000010 -5.34012535e-10 3.5100000 -5.34012535e-10 3.5100010 1.48280269e-09 3.5200000 1.48280269e-09 \
    3.5200010 0 3.5300000 0 3.5300010 -1.1998033e-09 3.5400000 -1.1998033e-09 \
    3.5400010 2.32079951e-10 3.5500000 2.32079951e-10 3.5500010 -9.41844773e-11 3.5600000 -9.41844773e-11 \
    3.5600010 0 3.5700000 0 3.5700010 1.49168259e-09 3.5800000 1.49168259e-09 \
    3.5800010 -5.74149461e-10 3.5900000 -5.74149461e-10 3.5900010 2.5914985e-10 3.6000000 2.5914985e-10 \
    3.6000010 1.20001413e-09 3.6100000 1.20001413e-09 3.6100010 0 3.6200000 0 \
    3.6200010 -1.13618681e-09 3.6300000 -1.13618681e-09 3.6300010 7.52525969e-10 3.6400000 7.52525969e-10 \
    3.6400010 -1.00834399e-09 3.6500000 -1.00834399e-09 3.6500010 1.2276816e-09 3.6600000 1.2276816e-09 \
    3.6600010 0 3.6700000 0 3.6700010 -1.08606385e-09 3.6800000 -1.08606385e-09 \
    3.6800010 1.06410774e-09 3.6900000 1.06410774e-09 3.6900010 0 3.7200000 0 \
    3.7200010 -7.27885285e-10 3.7300000 -7.27885285e-10 3.7300010 3.00295651e-10 3.7400000 3.00295651e-10 \
    3.7400010 1.19090676e-09 3.7500000 1.19090676e-09 3.7500010 4.79621401e-10 3.7600000 4.79621401e-10 \
    3.7600010 -9.65398304e-10 3.7700000 -9.65398304e-10 3.7700010 1.3163469e-09 3.7800000 1.3163469e-09 \
    3.7800010 -1.12709995e-09 3.7900000 -1.12709995e-09 3.7900010 1.42460222e-09 3.8000000 1.42460222e-09 \
    3.8000010 -1.21810081e-09 3.8100000 -1.21810081e-09 3.8100010 7.11321213e-10 3.8200000 7.11321213e-10 \
    3.8200010 0 3.8300000 0 3.8300010 -8.72888317e-10 3.8400000 -8.72888317e-10 \
    3.8400010 1.46434057e-09 3.8500000 1.46434057e-09 3.8500010 0 3.8600000 0 \
    3.8600010 -9.55025146e-10 3.8700000 -9.55025146e-10 3.8700010 1.66668025e-10 3.8800000 1.66668025e-10 \
    3.8800010 7.92456014e-10 3.8900000 7.92456014e-10 3.8900010 0 3.9000000 0 \
    3.9000010 2.6576981e-10 3.9100000 2.6576981e-10 3.9100010 0 3.9500000 0 \
    3.9500010 -1.34276431e-10 3.9600000 -1.34276431e-10 3.9600010 -1.0134715e-09 3.9700000 -1.0134715e-09 \
    3.9700010 3.74085074e-10 3.9800000 3.74085074e-10 3.9800010 4.02205414e-11 3.9900000 4.02205414e-11 \
    3.9900010 8.07687852e-11 4.0000000 8.07687852e-11 4.0000010 1.4592473e-09 4.0100000 1.4592473e-09 \
    4.0100010 0 4.0600000 0 ]
Rsh2 (n_ig2 0) resistor r=1G

X3 (n_in 0 n_ig3 n_rm3) ecfet_v3 Rinit=1642.09131525 A_stdp=0
ig3 (0 n_ig3) isource type=pwl wave=[ 0.0000000 0 0.0100000 0 0.0100010 1.14933605e-09 0.0200000 1.14933605e-09 \
    0.0200010 -9.95746604e-10 0.0300000 -9.95746604e-10 0.0300010 5.86113171e-11 0.0400000 5.86113171e-11 \
    0.0400010 6.28023007e-10 0.0500000 6.28023007e-10 0.0500010 0 0.0600000 0 \
    0.0600010 -1.25747305e-09 0.0700000 -1.25747305e-09 0.0700010 0 0.0800000 0 \
    0.0800010 5.75076293e-10 0.0900000 5.75076293e-10 0.0900010 0 0.1100000 0 \
    0.1100010 -1.17102958e-09 0.1200000 -1.17102958e-09 0.1200010 9.65231861e-10 0.1300000 9.65231861e-10 \
    0.1300010 0 0.1600000 0 0.1600010 -1.04996715e-09 0.1700000 -1.04996715e-09 \
    0.1700010 0 0.1800000 0 0.1800010 5.54162131e-10 0.1900000 5.54162131e-10 \
    0.1900010 5.7100356e-10 0.2000000 5.7100356e-10 0.2000010 -9.65422597e-10 0.2100000 -9.65422597e-10 \
    0.2100010 1.23572498e-09 0.2200000 1.23572498e-09 0.2200010 -9.49848294e-10 0.2300000 -9.49848294e-10 \
    0.2300010 1.74971971e-10 0.2400000 1.74971971e-10 0.2400010 8.38692409e-10 0.2500000 8.38692409e-10 \
    0.2500010 -9.90111524e-10 0.2600000 -9.90111524e-10 0.2600010 1.08438822e-09 0.2700000 1.08438822e-09 \
    0.2700010 0 0.2800000 0 0.2800010 7.17665969e-11 0.2900000 7.17665969e-11 \
    0.2900010 -9.82360833e-10 0.3000000 -9.82360833e-10 0.3000010 9.72174998e-10 0.3100000 9.72174998e-10 \
    0.3100010 1.99920996e-10 0.3200000 1.99920996e-10 0.3200010 0 0.3400000 0 \
    0.3400010 -1.17603548e-09 0.3500000 -1.17603548e-09 0.3500010 0 0.3600000 0 \
    0.3600010 1.24413428e-09 0.3700000 1.24413428e-09 0.3700010 0 0.3900000 0 \
    0.3900010 -8.00102563e-10 0.4000000 -8.00102563e-10 0.4000010 2.56905862e-10 0.4100000 2.56905862e-10 \
    0.4100010 0 0.4200000 0 0.4200010 -3.11366424e-10 0.4300000 -3.11366424e-10 \
    0.4300010 0 0.4400000 0 0.4400010 1.48893383e-09 0.4500000 1.48893383e-09 \
    0.4500010 0 0.4900000 0 0.4900010 1.86739094e-10 0.5000000 1.86739094e-10 \
    0.5000010 5.06227736e-11 0.5100000 5.06227736e-11 0.5100010 0 0.5200000 0 \
    0.5200010 -1.05835262e-09 0.5300000 -1.05835262e-09 0.5300010 7.74866721e-10 0.5400000 7.74866721e-10 \
    0.5400010 0 0.5500000 0 0.5500010 6.62675075e-10 0.5600000 6.62675075e-10 \
    0.5600010 -9.98762543e-10 0.5700000 -9.98762543e-10 0.5700010 0 0.5800000 0 \
    0.5800010 4.88607069e-10 0.5900000 4.88607069e-10 0.5900010 -8.02240168e-10 0.6000000 -8.02240168e-10 \
    0.6000010 2.32620626e-10 0.6100000 2.32620626e-10 0.6100010 1.21362796e-09 0.6200000 1.21362796e-09 \
    0.6200010 4.43008066e-10 0.6300000 4.43008066e-10 0.6300010 0 0.6400000 0 \
    0.6400010 4.76206849e-10 0.6500000 4.76206849e-10 0.6500010 0 0.6600000 0 \
    0.6600010 -8.29189885e-10 0.6700000 -8.29189885e-10 0.6700010 7.50598226e-10 0.6800000 7.50598226e-10 \
    0.6800010 -1.04670966e-09 0.6900000 -1.04670966e-09 0.6900010 1.40878815e-09 0.7000000 1.40878815e-09 \
    0.7000010 -9.42876224e-10 0.7100000 -9.42876224e-10 0.7100010 1.31073857e-09 0.7200000 1.31073857e-09 \
    0.7200010 0 0.7400000 0 0.7400010 -1.19410084e-09 0.7500000 -1.19410084e-09 \
    0.7500010 0 0.7700000 0 0.7700010 8.32579307e-10 0.7800000 8.32579307e-10 \
    0.7800010 0 0.7900000 0 0.7900010 -1.23780239e-09 0.8000000 -1.23780239e-09 \
    0.8000010 0 0.8100000 0 0.8100010 1.38830572e-09 0.8200000 1.38830572e-09 \
    0.8200010 0 0.8500000 0 0.8500010 -9.24126171e-10 0.8600000 -9.24126171e-10 \
    0.8600010 0 0.8700000 0 0.8700010 -4.74712084e-10 0.8800000 -4.74712084e-10 \
    0.8800010 1.32012103e-09 0.8900000 1.32012103e-09 0.8900010 -9.14496606e-10 0.9000000 -9.14496606e-10 \
    0.9000010 0 0.9100000 0 0.9100010 -1.00844319e-10 0.9200000 -1.00844319e-10 \
    0.9200010 7.69135164e-10 0.9300000 7.69135164e-10 0.9300010 2.48910339e-10 0.9400000 2.48910339e-10 \
    0.9400010 4.30088659e-10 0.9500000 4.30088659e-10 0.9500010 3.77629207e-10 0.9600000 3.77629207e-10 \
    0.9600010 -1.10729234e-09 0.9700000 -1.10729234e-09 0.9700010 9.64430243e-10 0.9800000 9.64430243e-10 \
    0.9800010 0 0.9900000 0 0.9900010 -1.19781262e-09 1.0000000 -1.19781262e-09 \
    1.0000010 1.13812282e-10 1.0100000 1.13812282e-10 1.0100010 9.35305723e-11 1.0200000 9.35305723e-11 \
    1.0200010 -5.12382993e-10 1.0300000 -5.12382993e-10 1.0300010 8.70092027e-10 1.0400000 8.70092027e-10 \
    1.0400010 0 1.0600000 0 1.0600010 -1.16842516e-09 1.0700000 -1.16842516e-09 \
    1.0700010 9.75340864e-10 1.0800000 9.75340864e-10 1.0800010 0 1.1100000 0 \
    1.1100010 -5.49660797e-10 1.1200000 -5.49660797e-10 1.1200010 8.23808751e-10 1.1300000 8.23808751e-10 \
    1.1300010 0 1.1600000 0 1.1600010 -1.02119504e-09 1.1700000 -1.02119504e-09 \
    1.1700010 6.96322134e-10 1.1800000 6.96322134e-10 1.1800010 0 1.1900000 0 \
    1.1900010 -1.00442687e-09 1.2000000 -1.00442687e-09 1.2000010 2.97783298e-10 1.2100000 2.97783298e-10 \
    1.2100010 1.29735374e-09 1.2200000 1.29735374e-09 1.2200010 0 1.2300000 0 \
    1.2300010 -1.2453878e-09 1.2400000 -1.2453878e-09 1.2400010 0 1.2500000 0 \
    1.2500010 -7.12996675e-10 1.2600000 -7.12996675e-10 1.2600010 1.17935474e-09 1.2700000 1.17935474e-09 \
    1.2700010 -8.23702742e-10 1.2800000 -8.23702742e-10 1.2800010 0 1.2900000 0 \
    1.2900010 -1.13984246e-10 1.3000000 -1.13984246e-10 1.3000010 1.40498229e-09 1.3100000 1.40498229e-09 \
    1.3100010 0 1.3500000 0 1.3500010 -9.70548295e-10 1.3600000 -9.70548295e-10 \
    1.3600010 1.08400891e-10 1.3700000 1.08400891e-10 1.3700010 5.87794404e-10 1.3800000 5.87794404e-10 \
    1.3800010 0 1.3900000 0 1.3900010 -1.09393123e-09 1.4000000 -1.09393123e-09 \
    1.4000010 2.71159119e-11 1.4100000 2.71159119e-11 1.4100010 1.15161289e-09 1.4200000 1.15161289e-09 \
    1.4200010 0 1.4500000 0 1.4500010 4.90463611e-10 1.4600000 4.90463611e-10 \
    1.4600010 0 1.5000000 0 1.5000010 -1.26638748e-09 1.5100000 -1.26638748e-09 \
    1.5100010 9.45994852e-10 1.5200000 9.45994852e-10 1.5200010 0 1.5500000 0 \
    1.5500010 2.89438204e-10 1.5600000 2.89438204e-10 1.5600010 1.83756344e-10 1.5700000 1.83756344e-10 \
    1.5700010 0 1.5900000 0 1.5900010 -1.2291342e-09 1.6000000 -1.2291342e-09 \
    1.6000010 -3.41547256e-10 1.6100000 -3.41547256e-10 1.6100010 1.18219137e-09 1.6200000 1.18219137e-09 \
    1.6200010 0 1.6500000 0 1.6500010 -1.08282375e-09 1.6600000 -1.08282375e-09 \
    1.6600010 8.94991488e-10 1.6700000 8.94991488e-10 1.6700010 0 1.7000000 0 \
    1.7000010 7.12005809e-10 1.7100000 7.12005809e-10 1.7100010 0 1.7500000 0 \
    1.7500010 2.12108078e-10 1.7600000 2.12108078e-10 1.7600010 -1.21846785e-09 1.7700000 -1.21846785e-09 \
    1.7700010 -3.41725984e-10 1.7800000 -3.41725984e-10 1.7800010 9.62833126e-10 1.7900000 9.62833126e-10 \
    1.7900010 -9.52310696e-10 1.8000000 -9.52310696e-10 1.8000010 5.5426393e-11 1.8100000 5.5426393e-11 \
    1.8100010 7.96752716e-10 1.8200000 7.96752716e-10 1.8200010 0 1.8300000 0 \
    1.8300010 3.64328713e-10 1.8400000 3.64328713e-10 1.8400010 -1.06215313e-09 1.8500000 -1.06215313e-09 \
    1.8500010 9.36293699e-10 1.8600000 9.36293699e-10 1.8600010 4.23284638e-10 1.8700000 4.23284638e-10 \
    1.8700010 2.53193015e-10 1.8800000 2.53193015e-10 1.8800010 0 1.8900000 0 \
    1.8900010 -1.20671574e-09 1.9000000 -1.20671574e-09 1.9000010 1.05597388e-09 1.9100000 1.05597388e-09 \
    1.9100010 0 1.9200000 0 1.9200010 -6.42061823e-10 1.9300000 -6.42061823e-10 \
    1.9300010 8.04035272e-10 1.9400000 8.04035272e-10 1.9400010 0 1.9500000 0 \
    1.9500010 6.62562576e-10 1.9600000 6.62562576e-10 1.9600010 -9.39823695e-10 1.9700000 -9.39823695e-10 \
    1.9700010 9.71699288e-10 1.9800000 9.71699288e-10 1.9800010 0 1.9900000 0 \
    1.9900010 -1.21273965e-09 2.0000000 -1.21273965e-09 2.0000010 -3.77060174e-10 2.0100000 -3.77060174e-10 \
    2.0100010 0 2.0200000 0 2.0200010 -5.21046164e-10 2.0300000 -5.21046164e-10 \
    2.0300010 0 2.0400000 0 2.0400010 7.56210287e-10 2.0500000 7.56210287e-10 \
    2.0500010 3.58502549e-10 2.0600000 3.58502549e-10 2.0600010 3.02099898e-10 2.0700000 3.02099898e-10 \
    2.0700010 4.02770504e-10 2.0800000 4.02770504e-10 2.0800010 -1.12024679e-09 2.0900000 -1.12024679e-09 \
    2.0900010 1.23385798e-09 2.1000000 1.23385798e-09 2.1000010 -1.23047548e-09 2.1100000 -1.23047548e-09 \
    2.1100010 2.42260053e-10 2.1200000 2.42260053e-10 2.1200010 1.33790451e-09 2.1300000 1.33790451e-09 \
    2.1300010 0 2.1600000 0 2.1600010 -1.13971595e-09 2.1700000 -1.13971595e-09 \
    2.1700010 8.7824774e-10 2.1800000 8.7824774e-10 2.1800010 0 2.1900000 0 \
    2.1900010 3.41346688e-10 2.2000000 3.41346688e-10 2.2000010 -1.21934169e-09 2.2100000 -1.21934169e-09 \
    2.2100010 0 2.2200000 0 2.2200010 1.36175545e-09 2.2300000 1.36175545e-09 \
    2.2300010 -9.36310825e-10 2.2400000 -9.36310825e-10 2.2400010 -1.9541394e-10 2.2500000 -1.9541394e-10 \
    2.2500010 9.19615003e-10 2.2600000 9.19615003e-10 2.2600010 -1.13257251e-09 2.2700000 -1.13257251e-09 \
    2.2700010 1.32545246e-10 2.2800000 1.32545246e-10 2.2800010 1.25091011e-09 2.2900000 1.25091011e-09 \
    2.2900010 0 2.3100000 0 2.3100010 -1.08396169e-09 2.3200000 -1.08396169e-09 \
    2.3200010 9.73636752e-10 2.3300000 9.73636752e-10 2.3300010 0 2.3400000 0 \
    2.3400010 -1.29295635e-09 2.3500000 -1.29295635e-09 2.3500010 2.08892673e-10 2.3600000 2.08892673e-10 \
    2.3600010 1.3747006e-09 2.3700000 1.3747006e-09 2.3700010 0 2.3900000 0 \
    2.3900010 1.01235544e-10 2.4000000 1.01235544e-10 2.4000010 -1.19600498e-09 2.4100000 -1.19600498e-09 \
    2.4100010 0 2.4200000 0 2.4200010 7.98127171e-10 2.4300000 7.98127171e-10 \
    2.4300010 0 2.4400000 0 2.4400010 3.90640846e-10 2.4500000 3.90640846e-10 \
    2.4500010 0 2.4900000 0 2.4900010 5.91679919e-10 2.5000000 5.91679919e-10 \
    2.5000010 0 2.5100000 0 2.5100010 1.71981377e-10 2.5200000 1.71981377e-10 \
    2.5200010 0 2.5600000 0 2.5600010 -1.08934394e-09 2.5700000 -1.08934394e-09 \
    2.5700010 6.8493157e-10 2.5800000 6.8493157e-10 2.5800010 0 2.5900000 0 \
    2.5900010 3.9214044e-10 2.6000000 3.9214044e-10 2.6000010 -1.29881213e-09 2.6100000 -1.29881213e-09 \
    2.6100010 1.22394995e-09 2.6200000 1.22394995e-09 2.6200010 0 2.6400000 0 \
    2.6400010 -1.28431846e-09 2.6500000 -1.28431846e-09 2.6500010 9.362578e-10 2.6600000 9.362578e-10 \
    2.6600010 1.11695033e-10 2.6700000 1.11695033e-10 2.6700010 0 2.7100000 0 \
    2.7100010 3.71859123e-10 2.7200000 3.71859123e-10 2.7200010 0 2.7600000 0 \
    2.7600010 -8.91377186e-10 2.7700000 -8.91377186e-10 2.7700010 9.59260865e-10 2.7800000 9.59260865e-10 \
    2.7800010 0 2.7900000 0 2.7900010 -1.23067118e-09 2.8000000 -1.23067118e-09 \
    2.8000010 1.91803391e-10 2.8100000 1.91803391e-10 2.8100010 3.15272269e-10 2.8200000 3.15272269e-10 \
    2.8200010 1.45531296e-09 2.8300000 1.45531296e-09 2.8300010 -9.97094374e-10 2.8400000 -9.97094374e-10 \
    2.8400010 2.07503445e-10 2.8500000 2.07503445e-10 2.8500010 1.44696757e-09 2.8600000 1.44696757e-09 \
    2.8600010 5.66316202e-10 2.8700000 5.66316202e-10 2.8700010 -1.05197051e-09 2.8800000 -1.05197051e-09 \
    2.8800010 -1.80619405e-10 2.8900000 -1.80619405e-10 2.8900010 9.56779483e-10 2.9000000 9.56779483e-10 \
    2.9000010 0 2.9100000 0 2.9100010 -1.21542258e-09 2.9200000 -1.21542258e-09 \
    2.9200010 0 2.9400000 0 2.9400010 2.0879926e-10 2.9500000 2.0879926e-10 \
    2.9500010 1.30968609e-09 2.9600000 1.30968609e-09 2.9600010 3.05692684e-10 2.9700000 3.05692684e-10 \
    2.9700010 0 2.9900000 0 2.9900010 -1.0593422e-09 3.0000000 -1.0593422e-09 \
    3.0000010 5.45036062e-11 3.0100000 5.45036062e-11 3.0100010 -1.02836821e-10 3.0200000 -1.02836821e-10 \
    3.0200010 1.41718614e-09 3.0300000 1.41718614e-09 3.0300010 -9.18541188e-10 3.0400000 -9.18541188e-10 \
    3.0400010 1.38647196e-09 3.0500000 1.38647196e-09 3.0500010 2.94897907e-10 3.0600000 2.94897907e-10 \
    3.0600010 4.03324984e-10 3.0700000 4.03324984e-10 3.0700010 -9.52672918e-10 3.0800000 -9.52672918e-10 \
    3.0800010 3.68042449e-10 3.0900000 3.68042449e-10 3.0900010 0 3.1000000 0 \
    3.1000010 1.94138418e-10 3.1100000 1.94138418e-10 3.1100010 8.25553801e-10 3.1200000 8.25553801e-10 \
    3.1200010 6.12540973e-10 3.1300000 6.12540973e-10 3.1300010 -1.1312987e-09 3.1400000 -1.1312987e-09 \
    3.1400010 -7.53866281e-11 3.1500000 -7.53866281e-11 3.1500010 -3.41122181e-10 3.1600000 -3.41122181e-10 \
    3.1600010 1.22929512e-09 3.1700000 1.22929512e-09 3.1700010 0 3.1900000 0 \
    3.1900010 5.9193579e-10 3.2000000 5.9193579e-10 3.2000010 -9.23061036e-10 3.2100000 -9.23061036e-10 \
    3.2100010 -6.62199315e-12 3.2200000 -6.62199315e-12 3.2200010 1.03010531e-10 3.2300000 1.03010531e-10 \
    3.2300010 1.02707516e-09 3.2400000 1.02707516e-09 3.2400010 4.34345874e-10 3.2500000 4.34345874e-10 \
    3.2500010 0 3.2600000 0 3.2600010 1.89176908e-10 3.2700000 1.89176908e-10 \
    3.2700010 0 3.2900000 0 3.2900010 -6.18759158e-10 3.3000000 -6.18759158e-10 \
    3.3000010 0 3.3100000 0 3.3100010 1.3603086e-09 3.3200000 1.3603086e-09 \
    3.3200010 -1.08303326e-09 3.3300000 -1.08303326e-09 3.3300010 1.8370716e-10 3.3400000 1.8370716e-10 \
    3.3400010 1.97216734e-10 3.3500000 1.97216734e-10 3.3500010 7.41196971e-10 3.3600000 7.41196971e-10 \
    3.3600010 -9.49841872e-10 3.3700000 -9.49841872e-10 3.3700010 1.00359944e-09 3.3800000 1.00359944e-09 \
    3.3800010 0 3.3900000 0 3.3900010 5.56035751e-10 3.4000000 5.56035751e-10 \
    3.4000010 -1.00905773e-09 3.4100000 -1.00905773e-09 3.4100010 1.21067655e-09 3.4200000 1.21067655e-09 \
    3.4200010 0 3.4400000 0 3.4400010 -8.34732551e-10 3.4500000 -8.34732551e-10 \
    3.4500010 0 3.4600000 0 3.4600010 -5.50407137e-10 3.4700000 -5.50407137e-10 \
    3.4700010 1.1577843e-09 3.4800000 1.1577843e-09 3.4800010 0 3.4900000 0 \
    3.4900010 -1.19529532e-09 3.5000000 -1.19529532e-09 3.5000010 7.93508672e-10 3.5100000 7.93508672e-10 \
    3.5100010 5.02935936e-10 3.5200000 5.02935936e-10 3.5200010 0 3.5400000 0 \
    3.5400010 3.29846049e-10 3.5500000 3.29846049e-10 3.5500010 0 3.5600000 0 \
    3.5600010 -1.01228004e-09 3.5700000 -1.01228004e-09 3.5700010 9.26355737e-10 3.5800000 9.26355737e-10 \
    3.5800010 0 3.5900000 0 3.5900010 6.366112e-10 3.6000000 6.366112e-10 \
    3.6000010 -1.21008655e-09 3.6100000 -1.21008655e-09 3.6100010 0 3.6200000 0 \
    3.6200010 6.96151703e-10 3.6300000 6.96151703e-10 3.6300010 0 3.6400000 0 \
    3.6400010 -1.16794849e-09 3.6500000 -1.16794849e-09 3.6500010 9.14273104e-10 3.6600000 9.14273104e-10 \
    3.6600010 0 3.6800000 0 3.6800010 -1.25822023e-09 3.6900000 -1.25822023e-09 \
    3.6900010 1.20682411e-09 3.7000000 1.20682411e-09 3.7000010 0 3.7100000 0 \
    3.7100010 6.99795527e-10 3.7200000 6.99795527e-10 3.7200010 0 3.7500000 0 \
    3.7500010 1.60970702e-10 3.7600000 1.60970702e-10 3.7600010 -1.14512003e-09 3.7700000 -1.14512003e-09 \
    3.7700010 9.64938255e-10 3.7800000 9.64938255e-10 3.7800010 0 3.7900000 0 \
    3.7900010 6.02472699e-10 3.8000000 6.02472699e-10 3.8000010 -9.15107397e-10 3.8100000 -9.15107397e-10 \
    3.8100010 1.89937712e-10 3.8200000 1.89937712e-10 3.8200010 1.30225399e-09 3.8300000 1.30225399e-09 \
    3.8300010 -9.07043837e-10 3.8400000 -9.07043837e-10 3.8400010 1.35582513e-09 3.8500000 1.35582513e-09 \
    3.8500010 4.77028585e-10 3.8600000 4.77028585e-10 3.8600010 0 3.8700000 0 \
    3.8700010 -1.09068646e-09 3.8800000 -1.09068646e-09 3.8800010 9.09197727e-10 3.8900000 9.09197727e-10 \
    3.8900010 -9.53688769e-10 3.9000000 -9.53688769e-10 3.9000010 9.68007088e-10 3.9100000 9.68007088e-10 \
    3.9100010 0 3.9300000 0 3.9300010 -1.2060991e-09 3.9400000 -1.2060991e-09 \
    3.9400010 7.21284748e-10 3.9500000 7.21284748e-10 3.9500010 -1.0841025e-09 3.9600000 -1.0841025e-09 \
    3.9600010 0 3.9700000 0 3.9700010 9.34008201e-10 3.9800000 9.34008201e-10 \
    3.9800010 0 3.9900000 0 3.9900010 -7.35301027e-10 4.0000000 -7.35301027e-10 \
    4.0000010 2.11400976e-10 4.0100000 2.11400976e-10 4.0100010 0 4.0600000 0 ]
Rsh3 (n_ig3 0) resistor r=1G

X4 (n_in 0 n_ig4 n_rm4) ecfet_v3 Rinit=1642.09131525 A_stdp=0
ig4 (0 n_ig4) isource type=pwl wave=[ 0.0000000 0 0.0100000 0 0.0100010 1.2212429e-09 0.0200000 1.2212429e-09 \
    0.0200010 -1.04428477e-09 0.0300000 -1.04428477e-09 0.0300010 1.11746623e-09 0.0400000 1.11746623e-09 \
    0.0400010 3.04923963e-10 0.0500000 3.04923963e-10 0.0500010 -1.00196884e-09 0.0600000 -1.00196884e-09 \
    0.0600010 3.12010098e-10 0.0700000 3.12010098e-10 0.0700010 0 0.0800000 0 \
    0.0800010 7.43491041e-10 0.0900000 7.43491041e-10 0.0900010 4.62597294e-10 0.1000000 4.62597294e-10 \
    0.1000010 0 0.1100000 0 0.1100010 -1.28590746e-09 0.1200000 -1.28590746e-09 \
    0.1200010 1.31112819e-09 0.1300000 1.31112819e-09 0.1300010 2.42787562e-10 0.1400000 2.42787562e-10 \
    0.1400010 0 0.1900000 0 0.1900010 1.2186369e-11 0.2000000 1.2186369e-11 \
    0.2000010 -1.1809085e-09 0.2100000 -1.1809085e-09 0.2100010 1.45483129e-09 0.2200000 1.45483129e-09 \
    0.2200010 0 0.2300000 0 0.2300010 -1.28201874e-09 0.2400000 -1.28201874e-09 \
    0.2400010 7.43468456e-10 0.2500000 7.43468456e-10 0.2500010 0 0.2800000 0 \
    0.2800010 1.95312185e-10 0.2900000 1.95312185e-10 0.2900010 -1.18640448e-09 0.3000000 -1.18640448e-09 \
    0.3000010 2.31831058e-10 0.3100000 2.31831058e-10 0.3100010 8.64271129e-10 0.3200000 8.64271129e-10 \
    0.3200010 0 0.3300000 0 0.3300010 -1.18206856e-09 0.3400000 -1.18206856e-09 \
    0.3400010 8.6632629e-10 0.3500000 8.6632629e-10 0.3500010 -1.06897212e-09 0.3600000 -1.06897212e-09 \
    0.3600010 5.95032505e-10 0.3700000 5.95032505e-10 0.3700010 0 0.3900000 0 \
    0.3900010 -9.82137671e-10 0.4000000 -9.82137671e-10 0.4000010 -3.75440844e-10 0.4100000 -3.75440844e-10 \
    0.4100010 0 0.4200000 0 0.4200010 5.27333188e-10 0.4300000 5.27333188e-10 \
    0.4300010 0 0.4500000 0 0.4500010 4.15780519e-10 0.4600000 4.15780519e-10 \
    0.4600010 0 0.4700000 0 0.4700010 -1.22868717e-09 0.4800000 -1.22868717e-09 \
    0.4800010 0 0.4900000 0 0.4900010 5.53976255e-10 0.5000000 5.53976255e-10 \
    0.5000010 -8.83837601e-10 0.5100000 -8.83837601e-10 0.5100010 0 0.5200000 0 \
    0.5200010 8.08928671e-10 0.5300000 8.08928671e-10 0.5300010 0 0.5500000 0 \
    0.5500010 -1.21273494e-09 0.5600000 -1.21273494e-09 0.5600010 0 0.5800000 0 \
    0.5800010 -1.033776e-10 0.5900000 -1.033776e-10 0.5900010 0 0.6000000 0 \
    0.6000010 -5.04684119e-10 0.6100000 -5.04684119e-10 0.6100010 7.25903959e-10 0.6200000 7.25903959e-10 \
    0.6200010 3.03377692e-10 0.6300000 3.03377692e-10 0.6300010 0 0.6500000 0 \
    0.6500010 -1.26261537e-09 0.6600000 -1.26261537e-09 0.6600010 0 0.6700000 0 \
    0.6700010 7.77582844e-10 0.6800000 7.77582844e-10 0.6800010 0 0.7000000 0 \
    0.7000010 -1.06418932e-09 0.7100000 -1.06418932e-09 0.7100010 -6.54618027e-10 0.7200000 -6.54618027e-10 \
    0.7200010 0 0.7400000 0 0.7400010 3.95700377e-10 0.7500000 3.95700377e-10 \
    0.7500010 0 0.7900000 0 0.7900010 3.76247896e-10 0.8000000 3.76247896e-10 \
    0.8000010 -1.08179061e-09 0.8100000 -1.08179061e-09 0.8100010 -2.76832487e-10 0.8200000 -2.76832487e-10 \
    0.8200010 9.01254173e-10 0.8300000 9.01254173e-10 0.8300010 0 0.8600000 0 \
    0.8600010 -6.55375036e-10 0.8700000 -6.55375036e-10 0.8700010 2.65169115e-10 0.8800000 2.65169115e-10 \
    0.8800010 8.23854374e-10 0.8900000 8.23854374e-10 0.8900010 5.06426725e-11 0.9000000 5.06426725e-11 \
    0.9000010 0 0.9400000 0 0.9400010 1.56177499e-10 0.9500000 1.56177499e-10 \
    0.9500010 0 0.9900000 0 0.9900010 4.56676897e-10 1.0000000 4.56676897e-10 \
    1.0000010 -1.28559093e-09 1.0100000 -1.28559093e-09 1.0100010 8.0042473e-10 1.0200000 8.0042473e-10 \
    1.0200010 -7.46483419e-10 1.0300000 -7.46483419e-10 1.0300010 1.12155301e-09 1.0400000 1.12155301e-09 \
    1.0400010 6.26756803e-11 1.0500000 6.26756803e-11 1.0500010 0 1.0800000 0 \
    1.0800010 4.76514384e-10 1.0900000 4.76514384e-10 1.0900010 0 1.1000000 0 \
    1.1000010 -1.17108138e-09 1.1100000 -1.17108138e-09 1.1100010 7.16702303e-10 1.1200000 7.16702303e-10 \
    1.1200010 0 1.1500000 0 1.1500010 2.27090598e-10 1.1600000 2.27090598e-10 \
    1.1600010 0 1.1900000 0 1.1900010 6.38521023e-10 1.2000000 6.38521023e-10 \
    1.2000010 -1.2858336e-09 1.2100000 -1.2858336e-09 1.2100010 7.01914433e-10 1.2200000 7.01914433e-10 \
    1.2200010 0 1.2500000 0 1.2500010 5.01017453e-10 1.2600000 5.01017453e-10 \
    1.2600010 0 1.3000000 0 1.3000010 6.07373251e-11 1.3100000 6.07373251e-11 \
    1.3100010 0 1.3500000 0 1.3500010 -1.12288343e-09 1.3600000 -1.12288343e-09 \
    1.3600010 1.20608004e-09 1.3700000 1.20608004e-09 1.3700010 0 1.3900000 0 \
    1.3900010 -1.25394875e-09 1.4000000 -1.25394875e-09 1.4000010 1.35052321e-09 1.4100000 1.35052321e-09 \
    1.4100010 0 1.4500000 0 1.4500010 4.06676446e-10 1.4600000 4.06676446e-10 \
    1.4600010 0 1.5000000 0 1.5000010 -7.57013492e-10 1.5100000 -7.57013492e-10 \
    1.5100010 9.0638844e-10 1.5200000 9.0638844e-10 1.5200010 0 1.5300000 0 \
    1.5300010 -1.03854547e-09 1.5400000 -1.03854547e-09 1.5400010 7.71951465e-10 1.5500000 7.71951465e-10 \
    1.5500010 0 1.5600000 0 1.5600010 1.46334796e-10 1.5700000 1.46334796e-10 \
    1.5700010 0 1.5900000 0 1.5900010 2.16790494e-10 1.6000000 2.16790494e-10 \
    1.6000010 1.14541226e-10 1.6100000 1.14541226e-10 1.6100010 2.81563926e-10 1.6200000 2.81563926e-10 \
    1.6200010 0 1.6300000 0 1.6300010 -1.09023878e-09 1.6400000 -1.09023878e-09 \
    1.6400010 -1.26094557e-10 1.6500000 -1.26094557e-10 1.6500010 0 1.6600000 0 \
    1.6600010 5.31861962e-10 1.6700000 5.31861962e-10 1.6700010 -9.04629216e-10 1.6800000 -9.04629216e-10 \
    1.6800010 1.28299559e-09 1.6900000 1.28299559e-09 1.6900010 0 1.7300000 0 \
    1.7300010 -1.09880415e-09 1.7400000 -1.09880415e-09 1.7400010 1.17120986e-09 1.7500000 1.17120986e-09 \
    1.7500010 3.69512719e-10 1.7600000 3.69512719e-10 1.7600010 -1.15612119e-09 1.7700000 -1.15612119e-09 \
    1.7700010 1.13853736e-09 1.7800000 1.13853736e-09 1.7800010 0 1.7900000 0 \
    1.7900010 -1.04767132e-09 1.8000000 -1.04767132e-09 1.8000010 1.46808871e-09 1.8100000 1.46808871e-09 \
    1.8100010 -1.26862011e-09 1.8200000 -1.26862011e-09 1.8200010 9.20479049e-10 1.8300000 9.20479049e-10 \
    1.8300010 0 1.8500000 0 1.8500010 -1.17408868e-09 1.8600000 -1.17408868e-09 \
    1.8600010 1.14810081e-09 1.8700000 1.14810081e-09 1.8700010 4.90794605e-10 1.8800000 4.90794605e-10 \
    1.8800010 0 1.8900000 0 1.8900010 -1.25268136e-09 1.9000000 -1.25268136e-09 \
    1.9000010 -2.30563032e-10 1.9100000 -2.30563032e-10 1.9100010 0 1.9200000 0 \
    1.9200010 7.20831548e-10 1.9300000 7.20831548e-10 1.9300010 0 1.9800000 0 \
    1.9800010 -1.17697844e-09 1.9900000 -1.17697844e-09 1.9900010 1.21235107e-09 2.0000000 1.21235107e-09 \
    2.0000010 3.24884549e-11 2.0100000 3.24884549e-11 2.0100010 0 2.0400000 0 \
    2.0400010 -1.28325364e-09 2.0500000 -1.28325364e-09 2.0500010 6.71975143e-10 2.0600000 6.71975143e-10 \
    2.0600010 2.35829353e-10 2.0700000 2.35829353e-10 2.0700010 0 2.1100000 0 \
    2.1100010 -1.17074938e-09 2.1200000 -1.17074938e-09 2.1200010 1.0008077e-09 2.1300000 1.0008077e-09 \
    2.1300010 -1.11226167e-09 2.1400000 -1.11226167e-09 2.1400010 0 2.1500000 0 \
    2.1500010 4.56897948e-10 2.1600000 4.56897948e-10 2.1600010 0 2.1900000 0 \
    2.1900010 3.01760027e-10 2.2000000 3.01760027e-10 2.2000010 -1.84880636e-10 2.2100000 -1.84880636e-10 \
    2.2100010 -1.00851659e-09 2.2200000 -1.00851659e-09 2.2200010 7.90023958e-10 2.2300000 7.90023958e-10 \
    2.2300010 0 2.2500000 0 2.2500010 -1.75773355e-10 2.2600000 -1.75773355e-10 \
    2.2600010 -1.09471189e-09 2.2700000 -1.09471189e-09 2.2700010 9.98608953e-10 2.2800000 9.98608953e-10 \
    2.2800010 0 2.3000000 0 2.3000010 7.16721735e-10 2.3100000 7.16721735e-10 \
    2.3100010 -9.819382e-10 2.3200000 -9.819382e-10 2.3200010 8.95216586e-10 2.3300000 8.95216586e-10 \
    2.3300010 0 2.3500000 0 2.3500010 4.20331833e-10 2.3600000 4.20331833e-10 \
    2.3600010 0 2.3900000 0 2.3900010 -2.01233901e-10 2.4000000 -2.01233901e-10 \
    2.4000010 5.30971208e-11 2.4100000 5.30971208e-11 2.4100010 0 2.4500000 0 \
    2.4500010 1.25034487e-10 2.4600000 1.25034487e-10 2.4600010 0 2.4800000 0 \
    2.4800010 -1.03931812e-09 2.4900000 -1.03931812e-09 2.4900010 1.10165923e-09 2.5000000 1.10165923e-09 \
    2.5000010 3.30977208e-10 2.5100000 3.30977208e-10 2.5100010 0 2.5500000 0 \
    2.5500010 -5.33448851e-11 2.5600000 -5.33448851e-11 2.5600010 0 2.5900000 0 \
    2.5900010 -1.32383786e-12 2.6000000 -1.32383786e-12 2.6000010 -1.58205436e-10 2.6100000 -1.58205436e-10 \
    2.6100010 0 2.6500000 0 2.6500010 -1.27685424e-09 2.6600000 -1.27685424e-09 \
    2.6600010 5.84899615e-10 2.6700000 5.84899615e-10 2.6700010 -1.1185664e-09 2.6800000 -1.1185664e-09 \
    2.6800010 1.2466461e-09 2.6900000 1.2466461e-09 2.6900010 0 2.7000000 0 \
    2.7000010 7.24775543e-10 2.7100000 7.24775543e-10 2.7100010 0 2.7500000 0 \
    2.7500010 4.05690813e-10 2.7600000 4.05690813e-10 2.7600010 0 2.7900000 0 \
    2.7900010 -1.21030076e-09 2.8000000 -1.21030076e-09 2.8000010 1.39145824e-09 2.8100000 1.39145824e-09 \
    2.8100010 0 2.8300000 0 2.8300010 -1.08934118e-09 2.8400000 -1.08934118e-09 \
    2.8400010 1.05769558e-09 2.8500000 1.05769558e-09 2.8500010 0 2.8800000 0 \
    2.8800010 -1.21042036e-09 2.8900000 -1.21042036e-09 2.8900010 7.29031521e-10 2.9000000 7.29031521e-10 \
    2.9000010 0 2.9100000 0 2.9100010 -1.09035309e-09 2.9200000 -1.09035309e-09 \
    2.9200010 0 2.9400000 0 2.9400010 -1.88344911e-10 2.9500000 -1.88344911e-10 \
    2.9500010 7.87627155e-11 2.9600000 7.87627155e-11 2.9600010 8.48778631e-10 2.9700000 8.48778631e-10 \
    2.9700010 0 2.9900000 0 2.9900010 -1.2713438e-09 3.0000000 -1.2713438e-09 \
    3.0000010 1.44946535e-09 3.0100000 1.44946535e-09 3.0100010 -7.79460823e-10 3.0200000 -7.79460823e-10 \
    3.0200010 1.30145398e-09 3.0300000 1.30145398e-09 3.0300010 -1.19088554e-09 3.0400000 -1.19088554e-09 \
    3.0400010 8.23563437e-10 3.0500000 8.23563437e-10 3.0500010 -1.24513505e-09 3.0600000 -1.24513505e-09 \
    3.0600010 5.72173413e-11 3.0700000 5.72173413e-11 3.0700010 0 3.0800000 0 \
    3.0800010 1.31624262e-09 3.0900000 1.31624262e-09 3.0900010 0 3.1100000 0 \
    3.1100010 -1.04131507e-09 3.1200000 -1.04131507e-09 3.1200010 6.61952449e-10 3.1300000 6.61952449e-10 \
    3.1300010 -1.10887946e-09 3.1400000 -1.10887946e-09 3.1400010 9.16943019e-10 3.1500000 9.16943019e-10 \
    3.1500010 -1.29299967e-09 3.1600000 -1.29299967e-09 3.1600010 7.32332472e-10 3.1700000 7.32332472e-10 \
    3.1700010 0 3.1900000 0 3.1900010 1.53703707e-13 3.2000000 1.53703707e-13 \
    3.2000010 -1.21686564e-09 3.2100000 -1.21686564e-09 3.2100010 -5.1273067e-10 3.2200000 -5.1273067e-10 \
    3.2200010 1.3321772e-09 3.2300000 1.3321772e-09 3.2300010 0 3.2400000 0 \
    3.2400010 3.11209721e-10 3.2500000 3.11209721e-10 3.2500010 4.29714432e-10 3.2600000 4.29714432e-10 \
    3.2600010 0 3.2700000 0 3.2700010 2.54931528e-10 3.2800000 2.54931528e-10 \
    3.2800010 -1.19679562e-09 3.2900000 -1.19679562e-09 3.2900010 5.94805197e-10 3.3000000 5.94805197e-10 \
    3.3000010 -1.11639038e-09 3.3100000 -1.11639038e-09 3.3100010 -1.08100196e-10 3.3200000 -1.08100196e-10 \
    3.3200010 -1.97332208e-10 3.3300000 -1.97332208e-10 3.3300010 1.16131238e-09 3.3400000 1.16131238e-09 \
    3.3400010 -1.1789799e-09 3.3500000 -1.1789799e-09 3.3500010 9.98566953e-10 3.3600000 9.98566953e-10 \
    3.3600010 0 3.3900000 0 3.3900010 -2.97943894e-11 3.4000000 -2.97943894e-11 \
    3.4000010 -1.25180002e-09 3.4100000 -1.25180002e-09 3.4100010 -4.39938233e-10 3.4200000 -4.39938233e-10 \
    3.4200010 1.4492897e-09 3.4300000 1.4492897e-09 3.4300010 -8.62061913e-10 3.4400000 -8.62061913e-10 \
    3.4400010 9.66536868e-10 3.4500000 9.66536868e-10 3.4500010 0 3.4800000 0 \
    3.4800010 7.3646543e-10 3.4900000 7.3646543e-10 3.4900010 0 3.5100000 0 \
    3.5100010 -1.24526808e-09 3.5200000 -1.24526808e-09 3.5200010 0 3.5300000 0 \
    3.5300010 -7.46865835e-10 3.5400000 -7.46865835e-10 3.5400010 1.18320729e-09 3.5500000 1.18320729e-09 \
    3.5500010 0 3.5900000 0 3.5900010 5.38045788e-11 3.6000000 5.38045788e-11 \
    3.6000010 1.00476993e-10 3.6100000 1.00476993e-10 3.6100010 0 3.6300000 0 \
    3.6300010 -1.27010044e-09 3.6400000 -1.27010044e-09 3.6400010 0 3.6500000 0 \
    3.6500010 7.72734746e-10 3.6600000 7.72734746e-10 3.6600010 0 3.6800000 0 \
    3.6800010 -1.06802361e-09 3.6900000 -1.06802361e-09 3.6900010 1.02460596e-09 3.7000000 1.02460596e-09 \
    3.7000010 0 3.7100000 0 3.7100010 -1.1076433e-09 3.7200000 -1.1076433e-09 \
    3.7200010 1.20127638e-09 3.7300000 1.20127638e-09 3.7300010 -1.0348625e-09 3.7400000 -1.0348625e-09 \
    3.7400010 1.01716004e-09 3.7500000 1.01716004e-09 3.7500010 0 3.7600000 0 \
    3.7600010 -1.00791115e-09 3.7700000 -1.00791115e-09 3.7700010 9.28882401e-10 3.7800000 9.28882401e-10 \
    3.7800010 0 3.7900000 0 3.7900010 2.30823015e-11 3.8000000 2.30823015e-11 \
    3.8000010 -1.20592556e-09 3.8100000 -1.20592556e-09 3.8100010 7.25800382e-10 3.8200000 7.25800382e-10 \
    3.8200010 0 3.8300000 0 3.8300010 -9.10371767e-10 3.8400000 -9.10371767e-10 \
    3.8400010 1.39808833e-09 3.8500000 1.39808833e-09 3.8500010 6.50114147e-10 3.8600000 6.50114147e-10 \
    3.8600010 0 3.8800000 0 3.8800010 -1.10914966e-09 3.8900000 -1.10914966e-09 \
    3.8900010 1.03852487e-09 3.9000000 1.03852487e-09 3.9000010 0 3.9200000 0 \
    3.9200010 -6.02031914e-10 3.9300000 -6.02031914e-10 3.9300010 -4.91678868e-10 3.9400000 -4.91678868e-10 \
    3.9400010 1.36328398e-09 3.9500000 1.36328398e-09 3.9500010 0 3.9900000 0 \
    3.9900010 -1.26452052e-09 4.0000000 -1.26452052e-09 4.0000010 1.43935192e-09 4.0100000 1.43935192e-09 \
    4.0100010 0 4.0600000 0 ]
Rsh4 (n_ig4 0) resistor r=1G

X5 (n_in 0 n_ig5 n_rm5) ecfet_v3 Rinit=1642.09131525 A_stdp=0
ig5 (0 n_ig5) isource type=pwl wave=[ 0.0000000 0 0.0100000 0 0.0100010 1.45142072e-09 0.0200000 1.45142072e-09 \
    0.0200010 -1.13201699e-09 0.0300000 -1.13201699e-09 0.0300010 9.50512582e-10 0.0400000 9.50512582e-10 \
    0.0400010 -6.87149369e-10 0.0500000 -6.87149369e-10 0.0500010 0 0.0600000 0 \
    0.0600010 2.87295132e-11 0.0700000 2.87295132e-11 0.0700010 0 0.0800000 0 \
    0.0800010 -5.76038288e-10 0.0900000 -5.76038288e-10 0.0900010 7.02597307e-10 0.1000000 7.02597307e-10 \
    0.1000010 -8.81671987e-10 0.1100000 -8.81671987e-10 0.1100010 1.12413438e-10 0.1200000 1.12413438e-10 \
    0.1200010 -3.69918289e-10 0.1300000 -3.69918289e-10 0.1300010 6.39138024e-10 0.1400000 6.39138024e-10 \
    0.1400010 -1.22840523e-09 0.1500000 -1.22840523e-09 0.1500010 -3.20605785e-10 0.1600000 -3.20605785e-10 \
    0.1600010 0 0.1800000 0 0.1800010 3.73761961e-10 0.1900000 3.73761961e-10 \
    0.1900010 0 0.2000000 0 0.2000010 -1.134378e-09 0.2100000 -1.134378e-09 \
    0.2100010 6.70205183e-10 0.2200000 6.70205183e-10 0.2200010 -1.09299094e-09 0.2300000 -1.09299094e-09 \
    0.2300010 1.46258944e-09 0.2400000 1.46258944e-09 0.2400010 6.57593976e-10 0.2500000 6.57593976e-10 \
    0.2500010 -8.78476096e-10 0.2600000 -8.78476096e-10 0.2600010 3.38332773e-10 0.2700000 3.38332773e-10 \
    0.2700010 1.01031448e-09 0.2800000 1.01031448e-09 0.2800010 0 0.2900000 0 \
    0.2900010 -9.97149785e-10 0.3000000 -9.97149785e-10 0.3000010 1.30392697e-09 0.3100000 1.30392697e-09 \
    0.3100010 8.22690236e-11 0.3200000 8.22690236e-11 0.3200010 -1.03653057e-09 0.3300000 -1.03653057e-09 \
    0.3300010 1.26301361e-09 0.3400000 1.26301361e-09 0.3400010 5.86510586e-10 0.3500000 5.86510586e-10 \
    0.3500010 -1.13855638e-09 0.3600000 -1.13855638e-09 0.3600010 5.24325937e-10 0.3700000 5.24325937e-10 \
    0.3700010 0 0.4000000 0 0.4000010 -1.21112302e-09 0.4100000 -1.21112302e-09 \
    0.4100010 0 0.4200000 0 0.4200010 -4.14348619e-11 0.4300000 -4.14348619e-11 \
    0.4300010 0 0.4400000 0 0.4400010 -2.53492757e-10 0.4500000 -2.53492757e-10 \
    0.4500010 7.46815489e-10 0.4600000 7.46815489e-10 0.4600010 -1.19543666e-09 0.4700000 -1.19543666e-09 \
    0.4700010 1.28821745e-09 0.4800000 1.28821745e-09 0.4800010 0 0.4900000 0 \
    0.4900010 -7.21968435e-10 0.5000000 -7.21968435e-10 0.5000010 1.45593681e-09 0.5100000 1.45593681e-09 \
    0.5100010 -1.03739712e-09 0.5200000 -1.03739712e-09 0.5200010 2.59329512e-10 0.5300000 2.59329512e-10 \
    0.5300010 1.41013456e-09 0.5400000 1.41013456e-09 0.5400010 -9.98329561e-10 0.5500000 -9.98329561e-10 \
    0.5500010 1.08489629e-09 0.5600000 1.08489629e-09 0.5600010 0 0.6000000 0 \
    0.6000010 -1.26859752e-09 0.6100000 -1.26859752e-09 0.6100010 7.34169167e-10 0.6200000 7.34169167e-10 \
    0.6200010 0 0.6300000 0 0.6300010 -9.4841005e-10 0.6400000 -9.4841005e-10 \
    0.6400010 7.79320192e-10 0.6500000 7.79320192e-10 0.6500010 0 0.6800000 0 \
    0.6800010 -9.47928777e-10 0.6900000 -9.47928777e-10 0.6900010 9.95741608e-10 0.7000000 9.95741608e-10 \
    0.7000010 0 0.7300000 0 0.7300010 -6.84701794e-10 0.7400000 -6.84701794e-10 \
    0.7400010 1.29868987e-09 0.7500000 1.29868987e-09 0.7500010 0 0.7600000 0 \
    0.7600010 -6.42819156e-10 0.7700000 -6.42819156e-10 0.7700010 5.89373575e-10 0.7800000 5.89373575e-10 \
    0.7800010 0 0.8000000 0 0.8000010 -1.03515443e-09 0.8100000 -1.03515443e-09 \
    0.8100010 9.17955439e-10 0.8200000 9.17955439e-10 0.8200010 0 0.8300000 0 \
    0.8300010 -9.21964375e-10 0.8400000 -9.21964375e-10 0.8400010 1.00982468e-09 0.8500000 1.00982468e-09 \
    0.8500010 0 0.8800000 0 0.8800010 -1.21153113e-09 0.8900000 -1.21153113e-09 \
    0.8900010 8.6479809e-10 0.9000000 8.6479809e-10 0.9000010 0 0.9200000 0 \
    0.9200010 2.2667382e-10 0.9300000 2.2667382e-10 0.9300010 -9.3361096e-10 0.9400000 -9.3361096e-10 \
    0.9400010 1.10077259e-09 0.9500000 1.10077259e-09 0.9500010 0 0.9600000 0 \
    0.9600010 -1.12907453e-09 0.9700000 -1.12907453e-09 0.9700010 9.27469931e-10 0.9800000 9.27469931e-10 \
    0.9800010 0 0.9900000 0 0.9900010 -1.19268914e-09 1.0000000 -1.19268914e-09 \
    1.0000010 -2.37841924e-10 1.0100000 -2.37841924e-10 1.0100010 1.39269195e-09 1.0200000 1.39269195e-09 \
    1.0200010 -1.23898882e-09 1.0300000 -1.23898882e-09 1.0300010 1.24192695e-09 1.0400000 1.24192695e-09 \
    1.0400010 -1.17717065e-09 1.0500000 -1.17717065e-09 1.0500010 0 1.0600000 0 \
    1.0600010 1.3201883e-10 1.0700000 1.3201883e-10 1.0700010 1.42366083e-09 1.0800000 1.42366083e-09 \
    1.0800010 0 1.0900000 0 1.0900010 1.58621744e-10 1.1000000 1.58621744e-10 \
    1.1000010 -1.04016976e-09 1.1100000 -1.04016976e-09 1.1100010 -2.40243566e-10 1.1200000 -2.40243566e-10 \
    1.1200010 1.44867645e-09 1.1300000 1.44867645e-09 1.1300010 0 1.1400000 0 \
    1.1400010 -1.21111856e-09 1.1500000 -1.21111856e-09 1.1500010 4.17105685e-11 1.1600000 4.17105685e-11 \
    1.1600010 0 1.1700000 0 1.1700010 5.21734017e-10 1.1800000 5.21734017e-10 \
    1.1800010 0 1.2000000 0 1.2000010 -1.23157945e-09 1.2100000 -1.23157945e-09 \
    1.2100010 7.65315114e-10 1.2200000 7.65315114e-10 1.2200010 0 1.2500000 0 \
    1.2500010 7.87226171e-10 1.2600000 7.87226171e-10 1.2600010 -1.19606619e-09 1.2700000 -1.19606619e-09 \
    1.2700010 8.98001031e-10 1.2800000 8.98001031e-10 1.2800010 0 1.3000000 0 \
    1.3000010 3.30844177e-10 1.3100000 3.30844177e-10 1.3100010 0 1.3500000 0 \
    1.3500010 -1.03554895e-09 1.3600000 -1.03554895e-09 1.3600010 1.12971178e-09 1.3700000 1.12971178e-09 \
    1.3700010 0 1.4000000 0 1.4000010 -1.28440975e-09 1.4100000 -1.28440975e-09 \
    1.4100010 7.92412129e-10 1.4200000 7.92412129e-10 1.4200010 0 1.4500000 0 \
    1.4500010 -1.21772946e-09 1.4600000 -1.21772946e-09 1.4600010 0 1.4700000 0 \
    1.4700010 1.42471563e-09 1.4800000 1.42471563e-09 1.4800010 0 1.5000000 0 \
    1.5000010 -1.18943245e-09 1.5100000 -1.18943245e-09 1.5100010 1.07276473e-09 1.5200000 1.07276473e-09 \
    1.5200010 1.14648627e-10 1.5300000 1.14648627e-10 1.5300010 -1.12314144e-09 1.5400000 -1.12314144e-09 \
    1.5400010 -6.09969089e-10 1.5500000 -6.09969089e-10 1.5500010 7.06025998e-10 1.5600000 7.06025998e-10 \
    1.5600010 0 1.5900000 0 1.5900010 1.40718145e-10 1.6000000 1.40718145e-10 \
    1.6000010 3.43735884e-10 1.6100000 3.43735884e-10 1.6100010 2.12359156e-10 1.6200000 2.12359156e-10 \
    1.6200010 0 1.6300000 0 1.6300010 -1.28553954e-09 1.6400000 -1.28553954e-09 \
    1.6400010 6.73577893e-10 1.6500000 6.73577893e-10 1.6500010 0 1.6600000 0 \
    1.6600010 6.60809251e-10 1.6700000 6.60809251e-10 1.6700010 0 1.6800000 0 \
    1.6800010 -6.84166971e-10 1.6900000 -6.84166971e-10 1.6900010 0 1.7000000 0 \
    1.7000010 5.19179338e-10 1.7100000 5.19179338e-10 1.7100010 -1.07882479e-09 1.7200000 -1.07882479e-09 \
    1.7200010 1.44392751e-09 1.7300000 1.44392751e-09 1.7300010 0 1.8000000 0 \
    1.8000010 -1.23818216e-09 1.8100000 -1.23818216e-09 1.8100010 9.74959693e-10 1.8200000 9.74959693e-10 \
    1.8200010 0 1.8300000 0 1.8300010 4.35671642e-10 1.8400000 4.35671642e-10 \
    1.8400010 0 1.8800000 0 1.8800010 -1.07736234e-09 1.8900000 -1.07736234e-09 \
    1.8900010 9.83178014e-10 1.9000000 9.83178014e-10 1.9000010 0 1.9200000 0 \
    1.9200010 7.20552242e-10 1.9300000 7.20552242e-10 1.9300010 3.69059564e-10 1.9400000 3.69059564e-10 \
    1.9400010 0 1.9500000 0 1.9500010 -1.23263653e-09 1.9600000 -1.23263653e-09 \
    1.9600010 0 1.9700000 0 1.9700010 6.39566431e-10 1.9800000 6.39566431e-10 \
    1.9800010 0 2.0000000 0 2.0000010 1.92976352e-10 2.0100000 1.92976352e-10 \
    2.0100010 -9.77144591e-10 2.0200000 -9.77144591e-10 2.0200010 -2.42541036e-10 2.0300000 -2.42541036e-10 \
    2.0300010 0 2.0400000 0 2.0400010 6.5330218e-10 2.0500000 6.5330218e-10 \
    2.0500010 0 2.0600000 0 2.0600010 4.86679916e-10 2.0700000 4.86679916e-10 \
    2.0700010 0 2.1100000 0 2.1100010 -1.15618152e-09 2.1200000 -1.15618152e-09 \
    2.1200010 1.02626339e-09 2.1300000 1.02626339e-09 2.1300010 0 2.2000000 0 \
    2.2000010 1.96597684e-10 2.2100000 1.96597684e-10 2.2100010 -1.11791654e-09 2.2200000 -1.11791654e-09 \
    2.2200010 -5.90953309e-10 2.2300000 -5.90953309e-10 2.2300010 0 2.2400000 0 \
    2.2400010 4.61946304e-10 2.2500000 4.61946304e-10 2.2500010 0 2.2700000 0 \
    2.2700010 5.36436966e-10 2.2800000 5.36436966e-10 2.2800010 0 2.3000000 0 \
    2.3000010 -7.28556106e-10 2.3100000 -7.28556106e-10 2.3100010 0 2.3200000 0 \
    2.3200010 -6.79823835e-10 2.3300000 -6.79823835e-10 2.3300010 0 2.3400000 0 \
    2.3400010 3.15105084e-10 2.3500000 3.15105084e-10 2.3500010 1.24214871e-09 2.3600000 1.24214871e-09 \
    2.3600010 0 2.4000000 0 2.4000010 2.53974886e-11 2.4100000 2.53974886e-11 \
    2.4100010 -1.05268862e-09 2.4200000 -1.05268862e-09 2.4200010 9.36384874e-10 2.4300000 9.36384874e-10 \
    2.4300010 -1.28572183e-09 2.4400000 -1.28572183e-09 2.4400010 -4.19360384e-10 2.4500000 -4.19360384e-10 \
    2.4500010 -7.84189366e-11 2.4600000 -7.84189366e-11 2.4600010 1.23150544e-10 2.4700000 1.23150544e-10 \
    2.4700010 0 2.4800000 0 2.4800010 -5.33317803e-10 2.4900000 -5.33317803e-10 \
    2.4900010 1.48570621e-09 2.5000000 1.48570621e-09 2.5000010 0 2.5100000 0 \
    2.5100010 -6.42186403e-10 2.5200000 -6.42186403e-10 2.5200010 0 2.5300000 0 \
    2.5300010 -4.42522157e-12 2.5400000 -4.42522157e-12 2.5400010 7.11200976e-10 2.5500000 7.11200976e-10 \
    2.5500010 -1.26800292e-09 2.5600000 -1.26800292e-09 2.5600010 0 2.5700000 0 \
    2.5700010 5.05061351e-10 2.5800000 5.05061351e-10 2.5800010 0 2.6000000 0 \
    2.6000010 1.06162099e-10 2.6100000 1.06162099e-10 2.6100010 0 2.6300000 0 \
    2.6300010 -9.45413598e-10 2.6400000 -9.45413598e-10 2.6400010 -1.51529493e-11 2.6500000 -1.51529493e-11 \
    2.6500010 1.13005441e-09 2.6600000 1.13005441e-09 2.6600010 -7.86917057e-10 2.6700000 -7.86917057e-10 \
    2.6700010 0 2.6800000 0 2.6800010 -6.8120803e-11 2.6900000 -6.8120803e-11 \
    2.6900010 0 2.7000000 0 2.7000010 4.48972753e-10 2.7100000 4.48972753e-10 \
    2.7100010 -1.54452512e-11 2.7200000 -1.54452512e-11 2.7200010 1.28489311e-09 2.7300000 1.28489311e-09 \
    2.7300010 -1.09132096e-09 2.7400000 -1.09132096e-09 2.7400010 1.8717372e-10 2.7500000 1.8717372e-10 \
    2.7500010 9.41216925e-10 2.7600000 9.41216925e-10 2.7600010 0 2.7800000 0 \
    2.7800010 2.4972901e-10 2.7900000 2.4972901e-10 2.7900010 0 2.8000000 0 \
    2.8000010 -1.23066467e-09 2.8100000 -1.23066467e-09 2.8100010 -4.07506015e-10 2.8200000 -4.07506015e-10 \
    2.8200010 1.35692244e-09 2.8300000 1.35692244e-09 2.8300010 0 2.8600000 0 \
    2.8600010 5.13766109e-10 2.8700000 5.13766109e-10 2.8700010 0 2.9000000 0 \
    2.9000010 -9.40190205e-10 2.9100000 -9.40190205e-10 2.9100010 1.09368923e-09 2.9200000 1.09368923e-09 \
    2.9200010 0 2.9500000 0 2.9500010 -1.13156101e-09 2.9600000 -1.13156101e-09 \
    2.9600010 9.97676035e-10 2.9700000 9.97676035e-10 2.9700010 0 3.0000000 0 \
    3.0000010 4.73743347e-10 3.0100000 4.73743347e-10 3.0100010 0 3.0300000 0 \
    3.0300010 -1.12888974e-09 3.0400000 -1.12888974e-09 3.0400010 9.16795043e-10 3.0500000 9.16795043e-10 \
    3.0500010 -1.16898644e-09 3.0600000 -1.16898644e-09 3.0600010 7.54361168e-10 3.0700000 7.54361168e-10 \
    3.0700010 0 3.1000000 0 3.1000010 -1.1922552e-09 3.1100000 -1.1922552e-09 \
    3.1100010 9.42220751e-10 3.1200000 9.42220751e-10 3.1200010 0 3.1500000 0 \
    3.1500010 -1.24022761e-09 3.1600000 -1.24022761e-09 3.1600010 7.96177774e-10 3.1700000 7.96177774e-10 \
    3.1700010 0 3.2000000 0 3.2000010 -1.15556621e-09 3.2100000 -1.15556621e-09 \
    3.2100010 7.81283455e-10 3.2200000 7.81283455e-10 3.2200010 -1.09735151e-09 3.2300000 -1.09735151e-09 \
    3.2300010 9.47581727e-10 3.2400000 9.47581727e-10 3.2400010 0 3.2500000 0 \
    3.2500010 -1.2462347e-09 3.2600000 -1.2462347e-09 3.2600010 8.57021823e-10 3.2700000 8.57021823e-10 \
    3.2700010 0 3.3000000 0 3.3000010 -9.43857126e-10 3.3100000 -9.43857126e-10 \
    3.3100010 1.69053412e-10 3.3200000 1.69053412e-10 3.3200010 9.87737437e-10 3.3300000 9.87737437e-10 \
    3.3300010 0 3.4000000 0 3.4000010 -1.21041133e-09 3.4100000 -1.21041133e-09 \
    3.4100010 1.32436395e-09 3.4200000 1.32436395e-09 3.4200010 -1.29438977e-09 3.4300000 -1.29438977e-09 \
    3.4300010 0 3.4400000 0 3.4400010 -7.06156475e-10 3.4500000 -7.06156475e-10 \
    3.4500010 0 3.4600000 0 3.4600010 1.01098967e-09 3.4700000 1.01098967e-09 \
    3.4700010 0 3.5000000 0 3.5000010 -1.13349654e-09 3.5100000 -1.13349654e-09 \
    3.5100010 -2.14233338e-10 3.5200000 -2.14233338e-10 3.5200010 0 3.5300000 0 \
    3.5300010 7.10983173e-10 3.5400000 7.10983173e-10 3.5400010 0 3.5900000 0 \
    3.5900010 3.61219515e-10 3.6000000 3.61219515e-10 3.6000010 2.57450951e-10 3.6100000 2.57450951e-10 \
    3.6100010 0 3.6200000 0 3.6200010 -5.62026509e-10 3.6300000 -5.62026509e-10 \
    3.6300010 6.33643138e-10 3.6400000 6.33643138e-10 3.6400010 -1.04550901e-09 3.6500000 -1.04550901e-09 \
    3.6500010 1.45829536e-09 3.6600000 1.45829536e-09 3.6600010 -7.89258152e-10 3.6700000 -7.89258152e-10 \
    3.6700010 1.14194601e-10 3.6800000 1.14194601e-10 3.6800010 -4.79573317e-10 3.6900000 -4.79573317e-10 \
    3.6900010 1.49022968e-09 3.7000000 1.49022968e-09 3.7000010 -8.98765982e-10 3.7100000 -8.98765982e-10 \
    3.7100010 3.69525875e-11 3.7200000 3.69525875e-11 3.7200010 2.41414675e-10 3.7300000 2.41414675e-10 \
    3.7300010 1.19932492e-09 3.7400000 1.19932492e-09 3.7400010 0 3.7500000 0 \
    3.7500010 2.42848947e-10 3.7600000 2.42848947e-10 3.7600010 0 3.8000000 0 \
    3.8000010 -1.21715817e-09 3.8100000 -1.21715817e-09 3.8100010 7.12426706e-10 3.8200000 7.12426706e-10 \
    3.8200010 -9.56632984e-10 3.8300000 -9.56632984e-10 3.8300010 0 3.8400000 0 \
    3.8400010 6.62493518e-10 3.8500000 6.62493518e-10 3.8500010 -5.88099884e-10 3.8600000 -5.88099884e-10 \
    3.8600010 0 3.8700000 0 3.8700010 7.99513118e-10 3.8800000 7.99513118e-10 \
    3.8800010 -9.71686344e-10 3.8900000 -9.71686344e-10 3.8900010 8.27099392e-10 3.9000000 8.27099392e-10 \
    3.9000010 1.44447121e-10 3.9100000 1.44447121e-10 3.9100010 0 3.9500000 0 \
    3.9500010 -1.73218641e-10 3.9600000 -1.73218641e-10 3.9600010 -1.04253863e-09 3.9700000 -1.04253863e-09 \
    3.9700010 1.14142549e-09 3.9800000 1.14142549e-09 3.9800010 0 4.0000000 0 \
    4.0000010 -1.18344768e-09 4.0100000 -1.18344768e-09 4.0100010 0 4.0600000 0 ]
Rsh5 (n_ig5 0) resistor r=1G

X6 (n_in 0 n_ig6 n_rm6) ecfet_v3 Rinit=1642.09131525 A_stdp=0
ig6 (0 n_ig6) isource type=pwl wave=[ 0.0000000 0 0.0100000 0 0.0100010 1.36247878e-09 0.0200000 1.36247878e-09 \
    0.0200010 -1.00085551e-09 0.0300000 -1.00085551e-09 0.0300010 1.21685642e-09 0.0400000 1.21685642e-09 \
    0.0400010 0 0.0500000 0 0.0500010 -9.92744679e-10 0.0600000 -9.92744679e-10 \
    0.0600010 1.0706992e-09 0.0700000 1.0706992e-09 0.0700010 0 0.0800000 0 \
    0.0800010 7.07008555e-10 0.0900000 7.07008555e-10 0.0900010 0 0.1000000 0 \
    0.1000010 -9.5601702e-10 0.1100000 -9.5601702e-10 0.1100010 1.16335526e-09 0.1200000 1.16335526e-09 \
    0.1200010 0 0.1300000 0 0.1300010 5.62192597e-10 0.1400000 5.62192597e-10 \
    0.1400010 0 0.1500000 0 0.1500010 7.18303981e-10 0.1600000 7.18303981e-10 \
    0.1600010 0 0.1900000 0 0.1900010 6.77948356e-10 0.2000000 6.77948356e-10 \
    0.2000010 -1.22205044e-09 0.2100000 -1.22205044e-09 0.2100010 5.7723501e-10 0.2200000 5.7723501e-10 \
    0.2200010 0 0.2500000 0 0.2500010 -9.55625393e-10 0.2600000 -9.55625393e-10 \
    0.2600010 1.16431181e-09 0.2700000 1.16431181e-09 0.2700010 0 0.3000000 0 \
    0.3000010 -1.23925363e-09 0.3100000 -1.23925363e-09 0.3100010 9.09005213e-10 0.3200000 9.09005213e-10 \
    0.3200010 0 0.3500000 0 0.3500010 -9.17696054e-10 0.3600000 -9.17696054e-10 \
    0.3600010 1.47929301e-09 0.3700000 1.47929301e-09 0.3700010 0 0.3900000 0 \
    0.3900010 -7.94417274e-10 0.4000000 -7.94417274e-10 0.4000010 1.47331574e-09 0.4100000 1.47331574e-09 \
    0.4100010 -7.55833262e-10 0.4200000 -7.55833262e-10 0.4200010 4.05323027e-10 0.4300000 4.05323027e-10 \
    0.4300010 0 0.4400000 0 0.4400010 3.68246431e-12 0.4500000 3.68246431e-12 \
    0.4500010 7.19996471e-10 0.4600000 7.19996471e-10 0.4600010 0 0.4700000 0 \
    0.4700010 -9.86747452e-10 0.4800000 -9.86747452e-10 0.4800010 0 0.4900000 0 \
    0.4900010 1.44613387e-09 0.5000000 1.44613387e-09 0.5000010 4.09588378e-10 0.5100000 4.09588378e-10 \
    0.5100010 -1.1477605e-09 0.5200000 -1.1477605e-09 0.5200010 8.97428942e-10 0.5300000 8.97428942e-10 \
    0.5300010 1.91760911e-10 0.5400000 1.91760911e-10 0.5400010 0 0.5900000 0 \
    0.5900010 -7.74959354e-10 0.6000000 -7.74959354e-10 0.6000010 1.15657874e-10 0.6100000 1.15657874e-10 \
    0.6100010 1.48069802e-09 0.6200000 1.48069802e-09 0.6200010 0 0.6300000 0 \
    0.6300010 -1.078144e-09 0.6400000 -1.078144e-09 0.6400010 1.49047662e-09 0.6500000 1.49047662e-09 \
    0.6500010 -9.80434875e-10 0.6600000 -9.80434875e-10 0.6600010 0 0.6700000 0 \
    0.6700010 -7.83666029e-10 0.6800000 -7.83666029e-10 0.6800010 0 0.6900000 0 \
    0.6900010 1.16527677e-09 0.7000000 1.16527677e-09 0.7000010 0 0.7100000 0 \
    0.7100010 6.55133562e-10 0.7200000 6.55133562e-10 0.7200010 0 0.8000000 0 \
    0.8000010 -1.12567325e-09 0.8100000 -1.12567325e-09 0.8100010 -3.02210864e-10 0.8200000 -3.02210864e-10 \
    0.8200010 7.26738549e-10 0.8300000 7.26738549e-10 0.8300010 0 0.8600000 0 \
    0.8600010 -7.36892026e-10 0.8700000 -7.36892026e-10 0.8700010 1.04972328e-09 0.8800000 1.04972328e-09 \
    0.8800010 0 0.8900000 0 0.8900010 -1.28885903e-09 0.9000000 -1.28885903e-09 \
    0.9000010 0 0.9100000 0 0.9100010 1.04451151e-09 0.9200000 1.04451151e-09 \
    0.9200010 -1.19098226e-09 0.9300000 -1.19098226e-09 0.9300010 1.00215327e-09 0.9400000 1.00215327e-09 \
    0.9400010 0 0.9600000 0 0.9600010 -9.97573694e-10 0.9700000 -9.97573694e-10 \
    0.9700010 1.18898174e-09 0.9800000 1.18898174e-09 0.9800010 0 0.9900000 0 \
    0.9900010 -1.0921242e-09 1.0000000 -1.0921242e-09 1.0000010 1.45908727e-09 1.0100000 1.45908727e-09 \
    1.0100010 0 1.0400000 0 1.0400010 1.97299484e-10 1.0500000 1.97299484e-10 \
    1.0500010 0 1.0900000 0 1.0900010 -6.20972021e-11 1.1000000 -6.20972021e-11 \
    1.1000010 0 1.1100000 0 1.1100010 -1.1770945e-09 1.1200000 -1.1770945e-09 \
    1.1200010 9.1629593e-10 1.1300000 9.1629593e-10 1.1300010 0 1.1400000 0 \
    1.1400010 5.53160745e-10 1.1500000 5.53160745e-10 1.1500010 -1.13241137e-09 1.1600000 -1.13241137e-09 \
    1.1600010 0 1.1700000 0 1.1700010 4.95824448e-10 1.1800000 4.95824448e-10 \
    1.1800010 0 1.1900000 0 1.1900010 -1.01724329e-09 1.2000000 -1.01724329e-09 \
    1.2000010 1.48186429e-09 1.2100000 1.48186429e-09 1.2100010 0 1.2200000 0 \
    1.2200010 -8.57420941e-10 1.2300000 -8.57420941e-10 1.2300010 1.32948481e-09 1.2400000 1.32948481e-09 \
    1.2400010 0 1.2500000 0 1.2500010 -1.17424208e-09 1.2600000 -1.17424208e-09 \
    1.2600010 1.60953034e-10 1.2700000 1.60953034e-10 1.2700010 8.00601234e-10 1.2800000 8.00601234e-10 \
    1.2800010 0 1.2900000 0 1.2900010 -5.81288058e-10 1.3000000 -5.81288058e-10 \
    1.3000010 1.34714981e-09 1.3100000 1.34714981e-09 1.3100010 -1.06497062e-09 1.3200000 -1.06497062e-09 \
    1.3200010 8.17019399e-10 1.3300000 8.17019399e-10 1.3300010 -9.81287798e-10 1.3400000 -9.81287798e-10 \
    1.3400010 5.48131938e-11 1.3500000 5.48131938e-11 1.3500010 0 1.3600000 0 \
    1.3600010 1.37108537e-09 1.3700000 1.37108537e-09 1.3700010 0 1.3900000 0 \
    1.3900010 -1.06039887e-09 1.4000000 -1.06039887e-09 1.4000010 1.46381784e-09 1.4100000 1.46381784e-09 \
    1.4100010 -9.32121384e-10 1.4200000 -9.32121384e-10 1.4200010 0 1.4300000 0 \
    1.4300010 -3.50119694e-10 1.4400000 -3.50119694e-10 1.4400010 -7.89934112e-11 1.4500000 -7.89934112e-11 \
    1.4500010 -2.83220177e-12 1.4600000 -2.83220177e-12 1.4600010 0 1.4700000 0 \
    1.4700010 2.89769294e-10 1.4800000 2.89769294e-10 1.4800010 1.32089015e-09 1.4900000 1.32089015e-09 \
    1.4900010 0 1.5000000 0 1.5000010 -1.20528912e-09 1.5100000 -1.20528912e-09 \
    1.5100010 1.04464166e-09 1.5200000 1.04464166e-09 1.5200010 0 1.5300000 0 \
    1.5300010 -1.00651941e-09 1.5400000 -1.00651941e-09 1.5400010 8.22011105e-10 1.5500000 8.22011105e-10 \
    1.5500010 -2.37297362e-11 1.5600000 -2.37297362e-11 1.5600010 0 1.5900000 0 \
    1.5900010 -1.25789082e-09 1.6000000 -1.25789082e-09 1.6000010 1.07124195e-09 1.6100000 1.07124195e-09 \
    1.6100010 0 1.6300000 0 1.6300010 -1.2716266e-09 1.6400000 -1.2716266e-09 \
    1.6400010 6.88442426e-10 1.6500000 6.88442426e-10 1.6500010 -9.6633181e-10 1.6600000 -9.6633181e-10 \
    1.6600010 1.36303365e-09 1.6700000 1.36303365e-09 1.6700010 0 1.7000000 0 \
    1.7000010 7.43616067e-10 1.7100000 7.43616067e-10 1.7100010 0 1.7300000 0 \
    1.7300010 -1.06568203e-09 1.7400000 -1.06568203e-09 1.7400010 8.60828002e-10 1.7500000 8.60828002e-10 \
    1.7500010 0 1.7900000 0 1.7900010 -9.10143544e-10 1.8000000 -9.10143544e-10 \
    1.8000010 -2.61922862e-11 1.8100000 -2.61922862e-11 1.8100010 5.60469769e-10 1.8200000 5.60469769e-10 \
    1.8200010 0 1.8300000 0 1.8300010 8.01019259e-11 1.8400000 8.01019259e-11 \
    1.8400010 0 1.8500000 0 1.8500010 -1.20002606e-09 1.8600000 -1.20002606e-09 \
    1.8600010 8.2564098e-10 1.8700000 8.2564098e-10 1.8700010 0 1.8800000 0 \
    1.8800010 -1.17908441e-09 1.8900000 -1.17908441e-09 1.8900010 8.20413334e-10 1.9000000 8.20413334e-10 \
    1.9000010 0 1.9300000 0 1.9300010 1.10973971e-10 1.9400000 1.10973971e-10 \
    1.9400010 0 1.9900000 0 1.9900010 -1.15127405e-09 2.0000000 -1.15127405e-09 \
    2.0000010 1.18900824e-09 2.0100000 1.18900824e-09 2.0100010 0 2.0500000 0 \
    2.0500010 -8.34359922e-10 2.0600000 -8.34359922e-10 2.0600010 -2.64936095e-10 2.0700000 -2.64936095e-10 \
    2.0700010 9.42592445e-10 2.0800000 9.42592445e-10 2.0800010 0 2.1100000 0 \
    2.1100010 -1.0572796e-09 2.1200000 -1.0572796e-09 2.1200010 1.22789815e-09 2.1300000 1.22789815e-09 \
    2.1300010 0 2.1900000 0 2.1900010 -1.28555426e-09 2.2000000 -1.28555426e-09 \
    2.2000010 1.34059071e-09 2.2100000 1.34059071e-09 2.2100010 -8.93201857e-10 2.2200000 -8.93201857e-10 \
    2.2200010 1.00790827e-09 2.2300000 1.00790827e-09 2.2300010 0 2.2500000 0 \
    2.2500010 -1.67879662e-10 2.2600000 -1.67879662e-10 2.2600010 -9.69608644e-10 2.2700000 -9.69608644e-10 \
    2.2700010 1.27384293e-09 2.2800000 1.27384293e-09 2.2800010 0 2.3000000 0 \
    2.3000010 -1.27461937e-09 2.3100000 -1.27461937e-09 2.3100010 0 2.3200000 0 \
    2.3200010 1.13615819e-09 2.3300000 1.13615819e-09 2.3300010 0 2.3600000 0 \
    2.3600010 -1.17553378e-09 2.3700000 -1.17553378e-09 2.3700010 8.20493193e-10 2.3800000 8.20493193e-10 \
    2.3800010 0 2.3900000 0 2.3900010 -1.2939101e-09 2.4000000 -1.2939101e-09 \
    2.4000010 1.10862851e-09 2.4100000 1.10862851e-09 2.4100010 -8.90378908e-10 2.4200000 -8.90378908e-10 \
    2.4200010 1.41912848e-09 2.4300000 1.41912848e-09 2.4300010 0 2.4400000 0 \
    2.4400010 4.28654565e-10 2.4500000 4.28654565e-10 2.4500010 -9.71339978e-10 2.4600000 -9.71339978e-10 \
    2.4600010 1.1225067e-09 2.4700000 1.1225067e-09 2.4700010 -9.99969537e-10 2.4800000 -9.99969537e-10 \
    2.4800010 -3.40485093e-10 2.4900000 -3.40485093e-10 2.4900010 7.38996316e-10 2.5000000 7.38996316e-10 \
    2.5000010 -7.57074115e-10 2.5100000 -7.57074115e-10 2.5100010 6.46770171e-11 2.5200000 6.46770171e-11 \
    2.5200010 0 2.5300000 0 2.5300010 -2.92960047e-10 2.5400000 -2.92960047e-10 \
    2.5400010 8.65279384e-10 2.5500000 8.65279384e-10 2.5500010 -1.461288e-09 2.5600000 -1.461288e-09 \
    2.5600010 0 2.5700000 0 2.5700010 4.94542638e-10 2.5800000 4.94542638e-10 \
    2.5800010 0 2.5900000 0 2.5900010 2.32331566e-10 2.6000000 2.32331566e-10 \
    2.6000010 1.23396384e-10 2.6100000 1.23396384e-10 2.6100010 -1.06772542e-09 2.6200000 -1.06772542e-09 \
    2.6200010 -1.95518632e-10 2.6300000 -1.95518632e-10 2.6300010 0 2.6400000 0 \
    2.6400010 1.43281553e-09 2.6500000 1.43281553e-09 2.6500010 -1.16337421e-09 2.6600000 -1.16337421e-09 \
    2.6600010 1.41620617e-09 2.6700000 1.41620617e-09 2.6700010 0 2.6900000 0 \
    2.6900010 -7.29281078e-10 2.7000000 -7.29281078e-10 2.7000010 1.45637995e-10 2.7100000 1.45637995e-10 \
    2.7100010 1.34398283e-09 2.7200000 1.34398283e-09 2.7200010 0 2.7300000 0 \
    2.7300010 -1.14276979e-09 2.7400000 -1.14276979e-09 2.7400010 3.1090227e-10 2.7500000 3.1090227e-10 \
    2.7500010 -1.5422667e-10 2.7600000 -1.5422667e-10 2.7600010 0 2.7700000 0 \
    2.7700010 1.42694415e-09 2.7800000 1.42694415e-09 2.7800010 0 2.7900000 0 \
    2.7900010 -9.96160146e-10 2.8000000 -9.96160146e-10 2.8000010 3.96034866e-11 2.8100000 3.96034866e-11 \
    2.8100010 -3.94892948e-10 2.8200000 -3.94892948e-10 2.8200010 2.30716993e-10 2.8300000 2.30716993e-10 \
    2.8300010 0 2.8400000 0 2.8400010 2.5850425e-10 2.8500000 2.5850425e-10 \
    2.8500010 9.5342597e-10 2.8600000 9.5342597e-10 2.8600010 0 2.8700000 0 \
    2.8700010 -1.16795553e-09 2.8800000 -1.16795553e-09 2.8800010 -1.70340847e-10 2.8900000 -1.70340847e-10 \
    2.8900010 -4.14809947e-11 2.9000000 -4.14809947e-11 2.9000010 0 2.9100000 0 \
    2.9100010 1.45579955e-09 2.9200000 1.45579955e-09 2.9200010 0 2.9500000 0 \
    2.9500010 -1.13396593e-09 2.9600000 -1.13396593e-09 2.9600010 1.00769433e-09 2.9700000 1.00769433e-09 \
    2.9700010 0 2.9900000 0 2.9900010 -1.0261832e-09 3.0000000 -1.0261832e-09 \
    3.0000010 -7.34887215e-11 3.0100000 -7.34887215e-11 3.0100010 -5.70605852e-10 3.0200000 -5.70605852e-10 \
    3.0200010 7.38851406e-10 3.0300000 7.38851406e-10 3.0300010 -9.66066321e-10 3.0400000 -9.66066321e-10 \
    3.0400010 1.29252388e-09 3.0500000 1.29252388e-09 3.0500010 0 3.0600000 0 \
    3.0600010 4.12712404e-10 3.0700000 4.12712404e-10 3.0700010 0 3.1100000 0 \
    3.1100010 -9.88248222e-10 3.1200000 -9.88248222e-10 3.1200010 7.09722641e-10 3.1300000 7.09722641e-10 \
    3.1300010 0 3.1500000 0 3.1500010 4.68447057e-10 3.1600000 4.68447057e-10 \
    3.1600010 0 3.1900000 0 3.1900010 -1.28596597e-09 3.2000000 -1.28596597e-09 \
    3.2000010 0 3.2100000 0 3.2100010 -3.31832904e-10 3.2200000 -3.31832904e-10 \
    3.2200010 1.71053176e-10 3.2300000 1.71053176e-10 3.2300010 7.92499565e-10 3.2400000 7.92499565e-10 \
    3.2400010 -1.3674067e-09 3.2500000 -1.3674067e-09 3.2500010 9.67385449e-10 3.2600000 9.67385449e-10 \
    3.2600010 0 3.2700000 0 3.2700010 -1.20813818e-09 3.2800000 -1.20813818e-09 \
    3.2800010 0 3.2900000 0 3.2900010 5.56954865e-10 3.3000000 5.56954865e-10 \
    3.3000010 0 3.3100000 0 3.3100010 -6.17155196e-10 3.3200000 -6.17155196e-10 \
    3.3200010 -1.82501566e-10 3.3300000 -1.82501566e-10 3.3300010 -6.06828795e-12 3.3400000 -6.06828795e-12 \
    3.3400010 8.98885515e-10 3.3500000 8.98885515e-10 3.3500010 4.99181779e-10 3.3600000 4.99181779e-10 \
    3.3600010 0 3.3900000 0 3.3900010 6.71809067e-10 3.4000000 6.71809067e-10 \
    3.4000010 -1.21514614e-09 3.4100000 -1.21514614e-09 3.4100010 3.05930757e-10 3.4200000 3.05930757e-10 \
    3.4200010 1.2797353e-10 3.4300000 1.2797353e-10 3.4300010 0 3.4400000 0 \
    3.4400010 2.07543993e-10 3.4500000 2.07543993e-10 3.4500010 0 3.4600000 0 \
    3.4600010 5.86530893e-10 3.4700000 5.86530893e-10 3.4700010 4.27348787e-10 3.4800000 4.27348787e-10 \
    3.4800010 0 3.4900000 0 3.4900010 -9.78594328e-10 3.5000000 -9.78594328e-10 \
    3.5000010 1.18526054e-09 3.5100000 1.18526054e-09 3.5100010 0 3.5400000 0 \
    3.5400010 -9.50577748e-10 3.5500000 -9.50577748e-10 3.5500010 1.11974483e-09 3.5600000 1.11974483e-09 \
    3.5600010 0 3.5900000 0 3.5900010 -1.28634482e-09 3.6000000 -1.28634482e-09 \
    3.6000010 1.29443693e-09 3.6100000 1.29443693e-09 3.6100010 0 3.6400000 0 \
    3.6400010 -9.67742591e-10 3.6500000 -9.67742591e-10 3.6500010 1.33318283e-09 3.6600000 1.33318283e-09 \
    3.6600010 0 3.6900000 0 3.6900010 -1.2231324e-09 3.7000000 -1.2231324e-09 \
    3.7000010 0 3.7100000 0 3.7100010 6.04313625e-10 3.7200000 6.04313625e-10 \
    3.7200010 0 3.7400000 0 3.7400010 -1.2451664e-09 3.7500000 -1.2451664e-09 \
    3.7500010 8.73965422e-10 3.7600000 8.73965422e-10 3.7600010 0 3.7900000 0 \
    3.7900010 5.58214174e-10 3.8000000 5.58214174e-10 3.8000010 -1.20652278e-09 3.8100000 -1.20652278e-09 \
    3.8100010 -3.18370439e-10 3.8200000 -3.18370439e-10 3.8200010 1.00332908e-09 3.8300000 1.00332908e-09 \
    3.8300010 0 3.8400000 0 3.8400010 -1.1873031e-09 3.8500000 -1.1873031e-09 \
    3.8500010 8.70363195e-10 3.8600000 8.70363195e-10 3.8600010 0 3.8900000 0 \
    3.8900010 -1.20632157e-09 3.9000000 -1.20632157e-09 3.9000010 9.53773216e-10 3.9100000 9.53773216e-10 \
    3.9100010 0 3.9400000 0 3.9400010 5.44096122e-10 3.9500000 5.44096122e-10 \
    3.9500010 0 3.9900000 0 3.9900010 -1.03604222e-09 4.0000000 -1.03604222e-09 \
    4.0000010 9.3358187e-11 4.0100000 9.3358187e-11 4.0100010 0 4.0600000 0 ]
Rsh6 (n_ig6 0) resistor r=1G

X7 (n_in 0 n_ig7 n_rm7) ecfet_v3 Rinit=1642.09131525 A_stdp=0
ig7 (0 n_ig7) isource type=pwl wave=[ 0.0000000 0 0.0400000 0 0.0400010 5.33523822e-11 0.0500000 5.33523822e-11 \
    0.0500010 -1.15524101e-09 0.0600000 -1.15524101e-09 0.0600010 1.05675866e-09 0.0700000 1.05675866e-09 \
    0.0700010 0 0.1000000 0 0.1000010 -9.71052563e-10 0.1100000 -9.71052563e-10 \
    0.1100010 7.17226e-11 0.1200000 7.17226e-11 0.1200010 1.14279157e-09 0.1300000 1.14279157e-09 \
    0.1300010 4.32646194e-10 0.1400000 4.32646194e-10 0.1400010 -1.11856163e-09 0.1500000 -1.11856163e-09 \
    0.1500010 1.25654386e-09 0.1600000 1.25654386e-09 0.1600010 0 0.1800000 0 \
    0.1800010 -1.17063156e-09 0.1900000 -1.17063156e-09 0.1900010 1.06311182e-09 0.2000000 1.06311182e-09 \
    0.2000010 0 0.2100000 0 0.2100010 -1.26948684e-09 0.2200000 -1.26948684e-09 \
    0.2200010 0 0.2300000 0 0.2300010 -1.28084669e-10 0.2400000 -1.28084669e-10 \
    0.2400010 1.22567689e-09 0.2500000 1.22567689e-09 0.2500010 -1.04057312e-09 0.2600000 -1.04057312e-09 \
    0.2600010 2.39153305e-10 0.2700000 2.39153305e-10 0.2700010 7.25051568e-10 0.2800000 7.25051568e-10 \
    0.2800010 0 0.3000000 0 0.3000010 4.64808943e-10 0.3100000 4.64808943e-10 \
    0.3100010 0 0.3200000 0 0.3200010 -1.03536405e-09 0.3300000 -1.03536405e-09 \
    0.3300010 -2.56762394e-10 0.3400000 -2.56762394e-10 0.3400010 1.34769463e-09 0.3500000 1.34769463e-09 \
    0.3500010 -1.050564e-09 0.3600000 -1.050564e-09 0.3600010 6.16131368e-10 0.3700000 6.16131368e-10 \
    0.3700010 0 0.3800000 0 0.3800010 -1.22641682e-09 0.3900000 -1.22641682e-09 \
    0.3900010 0 0.4000000 0 0.4000010 8.42802058e-10 0.4100000 8.42802058e-10 \
    0.4100010 -8.32930655e-10 0.4200000 -8.32930655e-10 0.4200010 1.18042503e-09 0.4300000 1.18042503e-09 \
    0.4300010 -7.78253486e-10 0.4400000 -7.78253486e-10 0.4400010 2.55431456e-10 0.4500000 2.55431456e-10 \
    0.4500010 1.41534863e-09 0.4600000 1.41534863e-09 0.4600010 0 0.4700000 0 \
    0.4700010 5.97164319e-10 0.4800000 5.97164319e-10 0.4800010 0 0.4900000 0 \
    0.4900010 -7.18894987e-10 0.5000000 -7.18894987e-10 0.5000010 1.23288133e-09 0.5100000 1.23288133e-09 \
    0.5100010 -1.15113013e-09 0.5200000 -1.15113013e-09 0.5200010 1.33565686e-10 0.5300000 1.33565686e-10 \
    0.5300010 1.36286115e-09 0.5400000 1.36286115e-09 0.5400010 -9.52578308e-10 0.5500000 -9.52578308e-10 \
    0.5500010 1.49137527e-09 0.5600000 1.49137527e-09 0.5600010 0 0.5800000 0 \
    0.5800010 -1.21075754e-09 0.5900000 -1.21075754e-09 0.5900010 0 0.6000000 0 \
    0.6000010 8.82935877e-10 0.6100000 8.82935877e-10 0.6100010 -7.56511487e-10 0.6200000 -7.56511487e-10 \
    0.6200010 9.24359568e-10 0.6300000 9.24359568e-10 0.6300010 0 0.6500000 0 \
    0.6500010 -1.11921194e-09 0.6600000 -1.11921194e-09 0.6600010 0 0.6700000 0 \
    0.6700010 1.20920516e-09 0.6800000 1.20920516e-09 0.6800010 -1.09473476e-09 0.6900000 -1.09473476e-09 \
    0.6900010 1.23366268e-09 0.7000000 1.23366268e-09 0.7000010 -1.0893996e-09 0.7100000 -1.0893996e-09 \
    0.7100010 5.93691195e-10 0.7200000 5.93691195e-10 0.7200010 0 0.7300000 0 \
    0.7300010 -7.39108051e-10 0.7400000 -7.39108051e-10 0.7400010 -6.87599515e-11 0.7500000 -6.87599515e-11 \
    0.7500010 0 0.7700000 0 0.7700010 1.51687721e-10 0.7800000 1.51687721e-10 \
    0.7800010 -1.16536768e-09 0.7900000 -1.16536768e-09 0.7900010 1.24750243e-09 0.8000000 1.24750243e-09 \
    0.8000010 0 0.8100000 0 0.8100010 -1.21012104e-09 0.8200000 -1.21012104e-09 \
    0.8200010 6.87243909e-10 0.8300000 6.87243909e-10 0.8300010 0 0.8400000 0 \
    0.8400010 3.91635143e-10 0.8500000 3.91635143e-10 0.8500010 0 0.8900000 0 \
    0.8900010 -9.4898741e-11 0.9000000 -9.4898741e-11 0.9000010 0 0.9100000 0 \
    0.9100010 -1.07214815e-09 0.9200000 -1.07214815e-09 0.9200010 1.00468253e-09 0.9300000 1.00468253e-09 \
    0.9300010 0 0.9400000 0 0.9400010 1.3067127e-10 0.9500000 1.3067127e-10 \
    0.9500010 0 0.9800000 0 0.9800010 -1.22880155e-09 0.9900000 -1.22880155e-09 \
    0.9900010 -3.14327531e-10 1.0000000 -3.14327531e-10 1.0000010 9.27605753e-10 1.0100000 9.27605753e-10 \
    1.0100010 0 1.0200000 0 1.0200010 4.44456e-10 1.0300000 4.44456e-10 \
    1.0300010 0 1.0400000 0 1.0400010 5.7915884e-11 1.0500000 5.7915884e-11 \
    1.0500010 -9.27427049e-10 1.0600000 -9.27427049e-10 1.0600010 1.49782505e-09 1.0700000 1.49782505e-09 \
    1.0700010 -1.09023418e-09 1.0800000 -1.09023418e-09 1.0800010 1.34363042e-09 1.0900000 1.34363042e-09 \
    1.0900010 -9.9419576e-11 1.1000000 -9.9419576e-11 1.1000010 0 1.1100000 0 \
    1.1100010 -9.87195286e-10 1.1200000 -9.87195286e-10 1.1200010 8.25946244e-10 1.1300000 8.25946244e-10 \
    1.1300010 0 1.1800000 0 1.1800010 -1.11687826e-09 1.1900000 -1.11687826e-09 \
    1.1900010 1.50117957e-10 1.2000000 1.50117957e-10 1.2000010 8.43066344e-10 1.2100000 8.43066344e-10 \
    1.2100010 1.85000964e-10 1.2200000 1.85000964e-10 1.2200010 -1.01518814e-09 1.2300000 -1.01518814e-09 \
    1.2300010 7.56782029e-10 1.2400000 7.56782029e-10 1.2400010 0 1.2500000 0 \
    1.2500010 4.53198506e-10 1.2600000 4.53198506e-10 1.2600010 -1.03704249e-09 1.2700000 -1.03704249e-09 \
    1.2700010 -4.33871841e-10 1.2800000 -4.33871841e-10 1.2800010 0 1.2900000 0 \
    1.2900010 1.10713065e-09 1.3000000 1.10713065e-09 1.3000010 3.00667829e-10 1.3100000 3.00667829e-10 \
    1.3100010 0 1.3200000 0 1.3200010 -1.20236153e-09 1.3300000 -1.20236153e-09 \
    1.3300010 0 1.3400000 0 1.3400010 1.162977e-09 1.3500000 1.162977e-09 \
    1.3500010 0 1.3800000 0 1.3800010 -1.1120055e-09 1.3900000 -1.1120055e-09 \
    1.3900010 -3.32714478e-10 1.4000000 -3.32714478e-10 1.4000010 7.83534823e-10 1.4100000 7.83534823e-10 \
    1.4100010 2.70781714e-10 1.4200000 2.70781714e-10 1.4200010 -8.85893872e-10 1.4300000 -8.85893872e-10 \
    1.4300010 1.21048804e-09 1.4400000 1.21048804e-09 1.4400010 1.52104913e-10 1.4500000 1.52104913e-10 \
    1.4500010 0 1.4700000 0 1.4700010 -1.11613751e-09 1.4800000 -1.11613751e-09 \
    1.4800010 3.17794361e-10 1.4900000 3.17794361e-10 1.4900010 0 1.5000000 0 \
    1.5000010 -6.7655741e-10 1.5100000 -6.7655741e-10 1.5100010 2.67395773e-10 1.5200000 2.67395773e-10 \
    1.5200010 1.3634194e-09 1.5300000 1.3634194e-09 1.5300010 -1.03916976e-09 1.5400000 -1.03916976e-09 \
    1.5400010 8.21579005e-10 1.5500000 8.21579005e-10 1.5500010 9.76158313e-11 1.5600000 9.76158313e-11 \
    1.5600010 0 1.5800000 0 1.5800010 -1.219943e-09 1.5900000 -1.219943e-09 \
    1.5900010 1.16083461e-09 1.6000000 1.16083461e-09 1.6000010 -1.23753159e-09 1.6100000 -1.23753159e-09 \
    1.6100010 2.17462048e-10 1.6200000 2.17462048e-10 1.6200010 0 1.6300000 0 \
    1.6300010 1.33815794e-09 1.6400000 1.33815794e-09 1.6400010 2.19866173e-10 1.6500000 2.19866173e-10 \
    1.6500010 0 1.6600000 0 1.6600010 -1.26560116e-09 1.6700000 -1.26560116e-09 \
    1.6700010 0 1.6800000 0 1.6800010 -7.29101852e-10 1.6900000 -7.29101852e-10 \
    1.6900010 0 1.7000000 0 1.7000010 -2.61973301e-10 1.7100000 -2.61973301e-10 \
    1.7100010 0 1.7200000 0 1.7200010 1.20457841e-09 1.7300000 1.20457841e-09 \
    1.7300010 -9.40891544e-10 1.7400000 -9.40891544e-10 1.7400010 1.43916196e-09 1.7500000 1.43916196e-09 \
    1.7500010 0 1.7800000 0 1.7800010 4.34440701e-10 1.7900000 4.34440701e-10 \
    1.7900010 -1.05502764e-09 1.8000000 -1.05502764e-09 1.8000010 8.9951896e-10 1.8100000 8.9951896e-10 \
    1.8100010 1.93629161e-10 1.8200000 1.93629161e-10 1.8200010 0 1.8400000 0 \
    1.8400010 -1.10297183e-09 1.8500000 -1.10297183e-09 1.8500010 -1.269044e-10 1.8600000 -1.269044e-10 \
    1.8600010 1.16376283e-09 1.8700000 1.16376283e-09 1.8700010 0 1.9000000 0 \
    1.9000010 -1.06527195e-09 1.9100000 -1.06527195e-09 1.9100010 0 1.9200000 0 \
    1.9200010 6.95326178e-10 1.9300000 6.95326178e-10 1.9300010 -7.56744925e-11 1.9400000 -7.56744925e-11 \
    1.9400010 0 1.9500000 0 1.9500010 -1.07251765e-09 1.9600000 -1.07251765e-09 \
    1.9600010 0 1.9700000 0 1.9700010 7.45545837e-10 1.9800000 7.45545837e-10 \
    1.9800010 4.47630134e-10 1.9900000 4.47630134e-10 1.9900010 3.50144877e-10 2.0000000 3.50144877e-10 \
    2.0000010 0 2.0500000 0 2.0500010 -1.21016022e-09 2.0600000 -1.21016022e-09 \
    2.0600010 1.03622399e-09 2.0700000 1.03622399e-09 2.0700010 0 2.1000000 0 \
    2.1000010 -9.34780151e-10 2.1100000 -9.34780151e-10 2.1100010 2.34460122e-10 2.1200000 2.34460122e-10 \
    2.1200010 1.00890954e-09 2.1300000 1.00890954e-09 2.1300010 4.86211429e-10 2.1400000 4.86211429e-10 \
    2.1400010 0 2.1500000 0 2.1500010 -1.28352733e-09 2.1600000 -1.28352733e-09 \
    2.1600010 0 2.1700000 0 2.1700010 6.91978905e-10 2.1800000 6.91978905e-10 \
    2.1800010 4.11396274e-10 2.1900000 4.11396274e-10 2.1900010 5.81641051e-11 2.2000000 5.81641051e-11 \
    2.2000010 0 2.2500000 0 2.2500010 -1.27545391e-09 2.2600000 -1.27545391e-09 \
    2.2600010 0 2.2700000 0 2.2700010 7.34971598e-10 2.2800000 7.34971598e-10 \
    2.2800010 0 2.3000000 0 2.3000010 -1.14547858e-09 2.3100000 -1.14547858e-09 \
    2.3100010 0 2.3200000 0 2.3200010 6.57240402e-10 2.3300000 6.57240402e-10 \
    2.3300010 0 2.3500000 0 2.3500010 -1.00385977e-09 2.3600000 -1.00385977e-09 \
    2.3600010 1.23135567e-09 2.3700000 1.23135567e-09 2.3700010 0 2.3800000 0 \
    2.3800010 -8.52698407e-11 2.3900000 -8.52698407e-11 2.3900010 -1.45225981e-10 2.4000000 -1.45225981e-10 \
    2.4000010 0 2.4200000 0 2.4200010 6.57721759e-10 2.4300000 6.57721759e-10 \
    2.4300010 0 2.4600000 0 2.4600010 1.73195717e-10 2.4700000 1.73195717e-10 \
    2.4700010 0 2.4800000 0 2.4800010 6.70252102e-10 2.4900000 6.70252102e-10 \
    2.4900010 0 2.5000000 0 2.5000010 -1.20485179e-09 2.5100000 -1.20485179e-09 \
    2.5100010 1.15421205e-09 2.5200000 1.15421205e-09 2.5200010 0 2.5400000 0 \
    2.5400010 -7.40722394e-10 2.5500000 -7.40722394e-10 2.5500010 8.87528025e-10 2.5600000 8.87528025e-10 \
    2.5600010 0 2.5800000 0 2.5800010 1.2080561e-10 2.5900000 1.2080561e-10 \
    2.5900010 -1.34543899e-10 2.6000000 -1.34543899e-10 2.6000010 0 2.6100000 0 \
    2.6100010 -1.06398177e-09 2.6200000 -1.06398177e-09 2.6200010 8.28934573e-10 2.6300000 8.28934573e-10 \
    2.6300010 0 2.6600000 0 2.6600010 5.11105005e-10 2.6700000 5.11105005e-10 \
    2.6700010 0 2.7000000 0 2.7000010 -1.16012401e-09 2.7100000 -1.16012401e-09 \
    2.7100010 -7.50413797e-11 2.7200000 -7.50413797e-11 2.7200010 -4.20461043e-10 2.7300000 -4.20461043e-10 \
    2.7300010 0 2.7400000 0 2.7400010 -2.71633614e-10 2.7500000 -2.71633614e-10 \
    2.7500010 7.44896278e-11 2.7600000 7.44896278e-11 2.7600010 0 2.7700000 0 \
    2.7700010 1.29920398e-09 2.7800000 1.29920398e-09 2.7800010 1.46417415e-10 2.7900000 1.46417415e-10 \
    2.7900010 -1.21653307e-09 2.8000000 -1.21653307e-09 2.8000010 8.22677815e-10 2.8100000 8.22677815e-10 \
    2.8100010 -1.26818709e-09 2.8200000 -1.26818709e-09 2.8200010 6.67908024e-10 2.8300000 6.67908024e-10 \
    2.8300010 0 2.8600000 0 2.8600010 3.73590062e-10 2.8700000 3.73590062e-10 \
    2.8700010 -1.21625917e-09 2.8800000 -1.21625917e-09 2.8800010 1.00835788e-09 2.8900000 1.00835788e-09 \
    2.8900010 0 2.9200000 0 2.9200010 -8.93838358e-10 2.9300000 -8.93838358e-10 \
    2.9300010 0 2.9400000 0 2.9400010 7.6324614e-10 2.9500000 7.6324614e-10 \
    2.9500010 0 2.9800000 0 2.9800010 -1.04311124e-09 2.9900000 -1.04311124e-09 \
    2.9900010 -2.9172619e-10 3.0000000 -2.9172619e-10 3.0000010 1.30309157e-09 3.0100000 1.30309157e-09 \
    3.0100010 -1.28740381e-09 3.0200000 -1.28740381e-09 3.0200010 7.47578712e-10 3.0300000 7.47578712e-10 \
    3.0300010 -1.09091476e-09 3.0400000 -1.09091476e-09 3.0400010 1.37524905e-09 3.0500000 1.37524905e-09 \
    3.0500010 0 3.0600000 0 3.0600010 3.51002256e-10 3.0700000 3.51002256e-10 \
    3.0700010 -1.01010995e-09 3.0800000 -1.01010995e-09 3.0800010 1.34284265e-09 3.0900000 1.34284265e-09 \
    3.0900010 0 3.1200000 0 3.1200010 5.41846466e-10 3.1300000 5.41846466e-10 \
    3.1300010 0 3.1600000 0 3.1600010 8.24938629e-11 3.1700000 8.24938629e-11 \
    3.1700010 0 3.1800000 0 3.1800010 -6.21382035e-10 3.1900000 -6.21382035e-10 \
    3.1900010 1.09849284e-09 3.2000000 1.09849284e-09 3.2000010 0 3.2200000 0 \
    3.2200010 -1.03865228e-09 3.2300000 -1.03865228e-09 3.2300010 1.05805921e-09 3.2400000 1.05805921e-09 \
    3.2400010 0 3.2700000 0 3.2700010 5.31768727e-10 3.2800000 5.31768727e-10 \
    3.2800010 -1.20580551e-09 3.2900000 -1.20580551e-09 3.2900010 5.85923366e-10 3.3000000 5.85923366e-10 \
    3.3000010 0 3.3200000 0 3.3200010 -1.13719998e-09 3.3300000 -1.13719998e-09 \
    3.3300010 1.37855401e-09 3.3400000 1.37855401e-09 3.3400010 0 3.3800000 0 \
    3.3800010 6.19100057e-10 3.3900000 6.19100057e-10 3.3900010 1.93411123e-11 3.4000000 1.93411123e-11 \
    3.4000010 0 3.4200000 0 3.4200010 -1.20142054e-09 3.4300000 -1.20142054e-09 \
    3.4300010 0 3.4400000 0 3.4400010 -7.4739842e-10 3.4500000 -7.4739842e-10 \
    3.4500010 0 3.4600000 0 3.4600010 5.78856592e-10 3.4700000 5.78856592e-10 \
    3.4700010 0 3.4900000 0 3.4900010 -9.94375614e-10 3.5000000 -9.94375614e-10 \
    3.5000010 -1.02832351e-10 3.5100000 -1.02832351e-10 3.5100010 7.56525355e-10 3.5200000 7.56525355e-10 \
    3.5200010 0 3.5300000 0 3.5300010 -1.2541646e-09 3.5400000 -1.2541646e-09 \
    3.5400010 1.03599824e-09 3.5500000 1.03599824e-09 3.5500010 -1.20410348e-09 3.5600000 -1.20410348e-09 \
    3.5600010 0 3.5700000 0 3.5700010 6.54037922e-10 3.5800000 6.54037922e-10 \
    3.5800010 5.72152382e-10 3.5900000 5.72152382e-10 3.5900010 1.96239747e-10 3.6000000 1.96239747e-10 \
    3.6000010 0 3.6200000 0 3.6200010 5.41370605e-10 3.6300000 5.41370605e-10 \
    3.6300010 1.44942258e-10 3.6400000 1.44942258e-10 3.6400010 -1.18451955e-09 3.6500000 -1.18451955e-09 \
    3.6500010 1.07026938e-10 3.6600000 1.07026938e-10 3.6600010 0 3.6700000 0 \
    3.6700010 9.22906892e-11 3.6800000 9.22906892e-11 3.6800010 2.57679157e-10 3.6900000 2.57679157e-10 \
    3.6900010 7.70327099e-10 3.7000000 7.70327099e-10 3.7000010 0 3.7100000 0 \
    3.7100010 -6.78366602e-10 3.7200000 -6.78366602e-10 3.7200010 -2.61440118e-10 3.7300000 -2.61440118e-10 \
    3.7300010 9.99828705e-10 3.7400000 9.99828705e-10 3.7400010 1.26109644e-10 3.7500000 1.26109644e-10 \
    3.7500010 4.30446923e-10 3.7600000 4.30446923e-10 3.7600010 -1.06300605e-09 3.7700000 -1.06300605e-09 \
    3.7700010 8.34826414e-10 3.7800000 8.34826414e-10 3.7800010 5.12997514e-10 3.7900000 5.12997514e-10 \
    3.7900010 1.22887611e-10 3.8000000 1.22887611e-10 3.8000010 0 3.8100000 0 \
    3.8100010 -1.20644209e-09 3.8200000 -1.20644209e-09 3.8200010 7.69653039e-10 3.8300000 7.69653039e-10 \
    3.8300010 -1.10095606e-09 3.8400000 -1.10095606e-09 3.8400010 1.2166909e-09 3.8500000 1.2166909e-09 \
    3.8500010 3.33004651e-10 3.8600000 3.33004651e-10 3.8600010 -8.99513241e-10 3.8700000 -8.99513241e-10 \
    3.8700010 1.48077031e-09 3.8800000 1.48077031e-09 3.8800010 0 3.8900000 0 \
    3.8900010 -1.17991384e-09 3.9000000 -1.17991384e-09 3.9000010 1.15847597e-09 3.9100000 1.15847597e-09 \
    3.9100010 0 3.9200000 0 3.9200010 5.8284626e-10 3.9300000 5.8284626e-10 \
    3.9300010 1.93814586e-10 3.9400000 1.93814586e-10 3.9400010 2.92350955e-10 3.9500000 2.92350955e-10 \
    3.9500010 2.90067354e-10 3.9600000 2.90067354e-10 3.9600010 0 3.9700000 0 \
    3.9700010 -1.08176171e-09 3.9800000 -1.08176171e-09 3.9800010 -2.72933728e-10 3.9900000 -2.72933728e-10 \
    3.9900010 -1.80194649e-10 4.0000000 -1.80194649e-10 4.0000010 9.25398987e-10 4.0100000 9.25398987e-10 \
    4.0100010 0 4.0600000 0 ]
Rsh7 (n_ig7 0) resistor r=1G

X8 (n_in 0 n_ig8 n_rm8) ecfet_v3 Rinit=1642.09131525 A_stdp=0
ig8 (0 n_ig8) isource type=pwl wave=[ 0.0000000 0 0.0200000 0 0.0200010 -9.91286579e-10 0.0300000 -9.91286579e-10 \
    0.0300010 2.19526166e-10 0.0400000 2.19526166e-10 0.0400010 -3.96769408e-10 0.0500000 -3.96769408e-10 \
    0.0500010 0 0.0600000 0 0.0600010 -5.15451214e-10 0.0700000 -5.15451214e-10 \
    0.0700010 0 0.0800000 0 0.0800010 5.32701385e-10 0.0900000 5.32701385e-10 \
    0.0900010 1.27208294e-09 0.1000000 1.27208294e-09 0.1000010 0 0.1100000 0 \
    0.1100010 -1.08220351e-09 0.1200000 -1.08220351e-09 0.1200010 2.70915302e-11 0.1300000 2.70915302e-11 \
    0.1300010 1.2909147e-09 0.1400000 1.2909147e-09 0.1400010 -1.22364146e-09 0.1500000 -1.22364146e-09 \
    0.1500010 1.30540451e-09 0.1600000 1.30540451e-09 0.1600010 0 0.1700000 0 \
    0.1700010 -7.48606084e-10 0.1800000 -7.48606084e-10 0.1800010 -4.05109777e-11 0.1900000 -4.05109777e-11 \
    0.1900010 1.05324763e-09 0.2000000 1.05324763e-09 0.2000010 0 0.2100000 0 \
    0.2100010 7.04681109e-10 0.2200000 7.04681109e-10 0.2200010 0 0.2300000 0 \
    0.2300010 -1.17635756e-09 0.2400000 -1.17635756e-09 0.2400010 1.05215151e-09 0.2500000 1.05215151e-09 \
    0.2500010 -1.11670894e-09 0.2600000 -1.11670894e-09 0.2600010 2.06524121e-10 0.2700000 2.06524121e-10 \
    0.2700010 1.4204655e-09 0.2800000 1.4204655e-09 0.2800010 4.34569342e-10 0.2900000 4.34569342e-10 \
    0.2900010 -1.10981824e-09 0.3000000 -1.10981824e-09 0.3000010 1.08199034e-09 0.3100000 1.08199034e-09 \
    0.3100010 -1.21066388e-09 0.3200000 -1.21066388e-09 0.3200010 0 0.3300000 0 \
    0.3300010 1.4972177e-09 0.3400000 1.4972177e-09 0.3400010 2.05023059e-10 0.3500000 2.05023059e-10 \
    0.3500010 -1.08945244e-09 0.3600000 -1.08945244e-09 0.3600010 5.72806363e-10 0.3700000 5.72806363e-10 \
    0.3700010 -1.03078323e-09 0.3800000 -1.03078323e-09 0.3800010 2.07415028e-10 0.3900000 2.07415028e-10 \
    0.3900010 0 0.4000000 0 0.4000010 1.23507842e-09 0.4100000 1.23507842e-09 \
    0.4100010 0 0.4400000 0 0.4400010 -1.06829668e-09 0.4500000 -1.06829668e-09 \
    0.4500010 8.07106267e-10 0.4600000 8.07106267e-10 0.4600010 0 0.4900000 0 \
    0.4900010 -1.2643967e-09 0.5000000 -1.2643967e-09 0.5000010 8.52565577e-10 0.5100000 8.52565577e-10 \
    0.5100010 0 0.5400000 0 0.5400010 -9.66389104e-10 0.5500000 -9.66389104e-10 \
    0.5500010 1.09850274e-09 0.5600000 1.09850274e-09 0.5600010 0 0.5900000 0 \
    0.5900010 -7.90734727e-10 0.6000000 -7.90734727e-10 0.6000010 1.49273216e-09 0.6100000 1.49273216e-09 \
    0.6100010 0 0.6200000 0 0.6200010 3.44085795e-10 0.6300000 3.44085795e-10 \
    0.6300010 0 0.6400000 0 0.6400010 5.69113009e-10 0.6500000 5.69113009e-10 \
    0.6500010 0 0.6900000 0 0.6900010 -1.22235775e-09 0.7000000 -1.22235775e-09 \
    0.7000010 0 0.7100000 0 0.7100010 4.71238411e-10 0.7200000 4.71238411e-10 \
    0.7200010 0 0.7400000 0 0.7400010 -1.05330579e-09 0.7500000 -1.05330579e-09 \
    0.7500010 0 0.7700000 0 0.7700010 1.44417663e-09 0.7800000 1.44417663e-09 \
    0.7800010 0 0.8000000 0 0.8000010 -1.06636165e-09 0.8100000 -1.06636165e-09 \
    0.8100010 -4.08273759e-10 0.8200000 -4.08273759e-10 0.8200010 -2.17044453e-10 0.8300000 -2.17044453e-10 \
    0.8300010 0 0.8400000 0 0.8400010 -4.08114407e-11 0.8500000 -4.08114407e-11 \
    0.8500010 0 0.8700000 0 0.8700010 -3.65989587e-10 0.8800000 -3.65989587e-10 \
    0.8800010 -3.94742047e-10 0.8900000 -3.94742047e-10 0.8900010 9.53060754e-10 0.9000000 9.53060754e-10 \
    0.9000010 0 0.9200000 0 0.9200010 -7.0279993e-10 0.9300000 -7.0279993e-10 \
    0.9300010 9.45760797e-10 0.9400000 9.45760797e-10 0.9400010 0 0.9500000 0 \
    0.9500010 4.27719514e-10 0.9600000 4.27719514e-10 0.9600010 -9.3061797e-10 0.9700000 -9.3061797e-10 \
    0.9700010 1.36679033e-09 0.9800000 1.36679033e-09 0.9800010 -1.28714154e-09 0.9900000 -1.28714154e-09 \
    0.9900010 -2.36702102e-10 1.0000000 -2.36702102e-10 1.0000010 4.39716462e-10 1.0100000 4.39716462e-10 \
    1.0100010 1.13658284e-09 1.0200000 1.13658284e-09 1.0200010 0 1.0300000 0 \
    1.0300010 5.36275261e-11 1.0400000 5.36275261e-11 1.0400010 0 1.0600000 0 \
    1.0600010 -1.08477759e-09 1.0700000 -1.08477759e-09 1.0700010 1.48618416e-09 1.0800000 1.48618416e-09 \
    1.0800010 5.15493807e-10 1.0900000 5.15493807e-10 1.0900010 0 1.1200000 0 \
    1.1200010 -1.19831557e-09 1.1300000 -1.19831557e-09 1.1300010 0 1.1400000 0 \
    1.1400010 5.4935252e-10 1.1500000 5.4935252e-10 1.1500010 0 1.1700000 0 \
    1.1700010 -1.24200967e-09 1.1800000 -1.24200967e-09 1.1800010 0 1.1900000 0 \
    1.1900010 7.17484814e-10 1.2000000 7.17484814e-10 1.2000010 0 1.2200000 0 \
    1.2200010 -8.69929291e-10 1.2300000 -8.69929291e-10 1.2300010 1.03156157e-09 1.2400000 1.03156157e-09 \
    1.2400010 0 1.2600000 0 1.2600010 -1.29249069e-09 1.2700000 -1.29249069e-09 \
    1.2700010 -4.67025336e-10 1.2800000 -4.67025336e-10 1.2800010 0 1.2900000 0 \
    1.2900010 5.61468754e-10 1.3000000 5.61468754e-10 1.3000010 0 1.3200000 0 \
    1.3200010 -1.18709311e-09 1.3300000 -1.18709311e-09 1.3300010 0 1.3400000 0 \
    1.3400010 4.68066443e-10 1.3500000 4.68066443e-10 1.3500010 0 1.3700000 0 \
    1.3700010 7.5472143e-10 1.3800000 7.5472143e-10 1.3800010 0 1.3900000 0 \
    1.3900010 5.96802322e-10 1.4000000 5.96802322e-10 1.4000010 0 1.4400000 0 \
    1.4400010 -1.04091108e-09 1.4500000 -1.04091108e-09 1.4500010 1.2828155e-09 1.4600000 1.2828155e-09 \
    1.4600010 0 1.4700000 0 1.4700010 -1.09111605e-09 1.4800000 -1.09111605e-09 \
    1.4800010 1.07821769e-09 1.4900000 1.07821769e-09 1.4900010 -8.83167386e-10 1.5000000 -8.83167386e-10 \
    1.5000010 -4.66745473e-11 1.5100000 -4.66745473e-11 1.5100010 1.2761587e-09 1.5200000 1.2761587e-09 \
    1.5200010 0 1.5500000 0 1.5500010 -1.24189621e-09 1.5600000 -1.24189621e-09 \
    1.5600010 1.25847165e-09 1.5700000 1.25847165e-09 1.5700010 -1.06817409e-09 1.5800000 -1.06817409e-09 \
    1.5800010 -6.34026404e-11 1.5900000 -6.34026404e-11 1.5900010 6.68726687e-10 1.6000000 6.68726687e-10 \
    1.6000010 -1.23974392e-09 1.6100000 -1.23974392e-09 1.6100010 -1.04953582e-10 1.6200000 -1.04953582e-10 \
    1.6200010 0 1.6300000 0 1.6300010 1.32042452e-09 1.6400000 1.32042452e-09 \
    1.6400010 -1.25673036e-09 1.6500000 -1.25673036e-09 1.6500010 0 1.6600000 0 \
    1.6600010 -6.79045465e-10 1.6700000 -6.79045465e-10 1.6700010 0 1.6800000 0 \
    1.6800010 1.4466825e-09 1.6900000 1.4466825e-09 1.6900010 0 1.7200000 0 \
    1.7200010 7.50264674e-10 1.7300000 7.50264674e-10 1.7300010 -1.11411615e-09 1.7400000 -1.11411615e-09 \
    1.7400010 7.87400777e-10 1.7500000 7.87400777e-10 1.7500010 -1.28473592e-09 1.7600000 -1.28473592e-09 \
    1.7600010 4.15009252e-10 1.7700000 4.15009252e-10 1.7700010 9.93465288e-10 1.7800000 9.93465288e-10 \
    1.7800010 0 1.7900000 0 1.7900010 -1.1360435e-09 1.8000000 -1.1360435e-09 \
    1.8000010 7.75455384e-10 1.8100000 7.75455384e-10 1.8100010 4.37588224e-10 1.8200000 4.37588224e-10 \
    1.8200010 -7.49996716e-11 1.8300000 -7.49996716e-11 1.8300010 -1.10717008e-09 1.8400000 -1.10717008e-09 \
    1.8400010 0 1.8500000 0 1.8500010 -2.54463737e-10 1.8600000 -2.54463737e-10 \
    1.8600010 8.41686397e-10 1.8700000 8.41686397e-10 1.8700010 4.24835039e-10 1.8800000 4.24835039e-10 \
    1.8800010 -9.60794429e-10 1.8900000 -9.60794429e-10 1.8900010 2.87736445e-10 1.9000000 2.87736445e-10 \
    1.9000010 1.07039312e-09 1.9100000 1.07039312e-09 1.9100010 0 1.9400000 0 \
    1.9400010 -9.96264076e-10 1.9500000 -9.96264076e-10 1.9500010 1.06464049e-09 1.9600000 1.06464049e-09 \
    1.9600010 -1.02527909e-09 1.9700000 -1.02527909e-09 1.9700010 1.45741565e-09 1.9800000 1.45741565e-09 \
    1.9800010 0 2.0200000 0 2.0200010 -7.1699855e-10 2.0300000 -7.1699855e-10 \
    2.0300010 0 2.0400000 0 2.0400010 1.04275984e-09 2.0500000 1.04275984e-09 \
    2.0500010 0 2.0700000 0 2.0700010 -2.85622398e-11 2.0800000 -2.85622398e-11 \
    2.0800010 -1.05527586e-09 2.0900000 -1.05527586e-09 2.0900010 1.45957425e-09 2.1000000 1.45957425e-09 \
    2.1000010 0 2.1100000 0 2.1100010 -7.58523347e-10 2.1200000 -7.58523347e-10 \
    2.1200010 -3.81248156e-10 2.1300000 -3.81248156e-10 2.1300010 -9.28248584e-12 2.1400000 -9.28248584e-12 \
    2.1400010 0 2.1500000 0 2.1500010 1.28980165e-09 2.1600000 1.28980165e-09 \
    2.1600010 0 2.1700000 0 2.1700010 -1.29591178e-09 2.1800000 -1.29591178e-09 \
    2.1800010 1.48283633e-09 2.1900000 1.48283633e-09 2.1900010 0 2.2000000 0 \
    2.2000010 4.52379372e-10 2.2100000 4.52379372e-10 2.2100010 0 2.2300000 0 \
    2.2300010 -1.1149476e-09 2.2400000 -1.1149476e-09 2.2400010 1.47876307e-09 2.2500000 1.47876307e-09 \
    2.2500010 3.96590733e-10 2.2600000 3.96590733e-10 2.2600010 -1.18237587e-09 2.2700000 -1.18237587e-09 \
    2.2700010 -1.81164803e-10 2.2800000 -1.81164803e-10 2.2800010 8.92544219e-10 2.2900000 8.92544219e-10 \
    2.2900010 0 2.3200000 0 2.3200010 6.09841815e-10 2.3300000 6.09841815e-10 \
    2.3300010 -8.47277427e-10 2.3400000 -8.47277427e-10 2.3400010 1.20344559e-09 2.3500000 1.20344559e-09 \
    2.3500010 -1.13747883e-09 2.3600000 -1.13747883e-09 2.3600010 1.94055598e-10 2.3700000 1.94055598e-10 \
    2.3700010 -4.40704105e-10 2.3800000 -4.40704105e-10 2.3800010 1.3948379e-09 2.3900000 1.3948379e-09 \
    2.3900010 0 2.4000000 0 2.4000010 3.25334379e-10 2.4100000 3.25334379e-10 \
    2.4100010 0 2.4200000 0 2.4200010 -1.1929553e-09 2.4300000 -1.1929553e-09 \
    2.4300010 1.13986686e-09 2.4400000 1.13986686e-09 2.4400010 1.56794319e-10 2.4500000 1.56794319e-10 \
    2.4500010 -1.1381069e-09 2.4600000 -1.1381069e-09 2.4600010 1.44829246e-09 2.4700000 1.44829246e-09 \
    2.4700010 0 2.4800000 0 2.4800010 -1.26823253e-09 2.4900000 -1.26823253e-09 \
    2.4900010 8.97091545e-10 2.5000000 8.97091545e-10 2.5000010 0 2.5100000 0 \
    2.5100010 3.67428109e-10 2.5200000 3.67428109e-10 2.5200010 0 2.5300000 0 \
    2.5300010 -1.1248648e-09 2.5400000 -1.1248648e-09 2.5400010 7.90991188e-10 2.5500000 7.90991188e-10 \
    2.5500010 0 2.5800000 0 2.5800010 4.35994402e-10 2.5900000 4.35994402e-10 \
    2.5900010 0 2.6100000 0 2.6100010 -1.13320247e-09 2.6200000 -1.13320247e-09 \
    2.6200010 1.00071821e-09 2.6300000 1.00071821e-09 2.6300010 -9.72352618e-10 2.6400000 -9.72352618e-10 \
    2.6400010 9.98275719e-10 2.6500000 9.98275719e-10 2.6500010 0 2.6800000 0 \
    2.6800010 -1.12595465e-09 2.6900000 -1.12595465e-09 2.6900010 0 2.7000000 0 \
    2.7000010 5.42584728e-10 2.7100000 5.42584728e-10 2.7100010 0 2.7300000 0 \
    2.7300010 -1.0866943e-09 2.7400000 -1.0866943e-09 2.7400010 8.78531387e-10 2.7500000 8.78531387e-10 \
    2.7500010 0 2.7800000 0 2.7800010 6.08565452e-10 2.7900000 6.08565452e-10 \
    2.7900010 0 2.8100000 0 2.8100010 -1.15637285e-09 2.8200000 -1.15637285e-09 \
    2.8200010 1.21231492e-09 2.8300000 1.21231492e-09 2.8300010 0 2.8400000 0 \
    2.8400010 -1.26999484e-09 2.8500000 -1.26999484e-09 2.8500010 -4.61831139e-10 2.8600000 -4.61831139e-10 \
    2.8600010 1.06256399e-10 2.8700000 1.06256399e-10 2.8700010 0 2.8800000 0 \
    2.8800010 6.98913274e-10 2.8900000 6.98913274e-10 2.8900010 -1.23979233e-09 2.9000000 -1.23979233e-09 \
    2.9000010 0 2.9100000 0 2.9100010 6.27931705e-10 2.9200000 6.27931705e-10 \
    2.9200010 0 2.9400000 0 2.9400010 -1.02051874e-09 2.9500000 -1.02051874e-09 \
    2.9500010 1.10923626e-09 2.9600000 1.10923626e-09 2.9600010 1.16724911e-10 2.9700000 1.16724911e-10 \
    2.9700010 0 2.9900000 0 2.9900010 -1.03720769e-09 3.0000000 -1.03720769e-09 \
    3.0000010 1.15322401e-09 3.0100000 1.15322401e-09 3.0100010 0 3.0400000 0 \
    3.0400010 -1.03207383e-09 3.0500000 -1.03207383e-09 3.0500010 1.11722545e-09 3.0600000 1.11722545e-09 \
    3.0600010 0 3.0900000 0 3.0900010 -7.55589289e-10 3.1000000 -7.55589289e-10 \
    3.1000010 1.05320269e-09 3.1100000 1.05320269e-09 3.1100010 0 3.1400000 0 \
    3.1400010 -1.09667555e-09 3.1500000 -1.09667555e-09 3.1500010 9.89120237e-10 3.1600000 9.89120237e-10 \
    3.1600010 0 3.1900000 0 3.1900010 6.82644161e-10 3.2000000 6.82644161e-10 \
    3.2000010 0 3.2200000 0 3.2200010 -1.17198066e-09 3.2300000 -1.17198066e-09 \
    3.2300010 8.30418922e-10 3.2400000 8.30418922e-10 3.2400010 6.29778509e-10 3.2500000 6.29778509e-10 \
    3.2500010 0 3.2900000 0 3.2900010 -1.21513574e-09 3.3000000 -1.21513574e-09 \
    3.3000010 0 3.3100000 0 3.3100010 7.40797401e-10 3.3200000 7.40797401e-10 \
    3.3200010 0 3.3400000 0 3.3400010 -1.0312748e-09 3.3500000 -1.0312748e-09 \
    3.3500010 1.07970479e-09 3.3600000 1.07970479e-09 3.3600010 0 3.3900000 0 \
    3.3900010 5.04509404e-10 3.4000000 5.04509404e-10 3.4000010 0 3.4400000 0 \
    3.4400010 -1.23165081e-09 3.4500000 -1.23165081e-09 3.4500010 0 3.4600000 0 \
    3.4600010 5.99516693e-10 3.4700000 5.99516693e-10 3.4700010 3.33553557e-10 3.4800000 3.33553557e-10 \
    3.4800010 0 3.4900000 0 3.4900010 -1.19809869e-09 3.5000000 -1.19809869e-09 \
    3.5000010 1.1872961e-09 3.5100000 1.1872961e-09 3.5100010 0 3.5400000 0 \
    3.5400010 -1.1356828e-09 3.5500000 -1.1356828e-09 3.5500010 1.08938998e-09 3.5600000 1.08938998e-09 \
    3.5600010 0 3.5900000 0 3.5900010 -1.26847812e-09 3.6000000 -1.26847812e-09 \
    3.6000010 9.65588552e-10 3.6100000 9.65588552e-10 3.6100010 0 3.6400000 0 \
    3.6400010 -9.72548073e-10 3.6500000 -9.72548073e-10 3.6500010 1.32000161e-09 3.6600000 1.32000161e-09 \
    3.6600010 0 3.6900000 0 3.6900010 -1.21181163e-09 3.7000000 -1.21181163e-09 \
    3.7000010 0 3.7100000 0 3.7100010 6.15691466e-10 3.7200000 6.15691466e-10 \
    3.7200010 0 3.7400000 0 3.7400010 -1.27508215e-09 3.7500000 -1.27508215e-09 \
    3.7500010 8.3331909e-10 3.7600000 8.3331909e-10 3.7600010 0 3.7800000 0 \
    3.7800010 -9.11447144e-10 3.7900000 -9.11447144e-10 3.7900010 9.09141186e-10 3.8000000 9.09141186e-10 \
    3.8000010 -1.02927513e-09 3.8100000 -1.02927513e-09 3.8100010 9.97251492e-10 3.8200000 9.97251492e-10 \
    3.8200010 -1.19834576e-09 3.8300000 -1.19834576e-09 3.8300010 0 3.8400000 0 \
    3.8400010 7.75489611e-10 3.8500000 7.75489611e-10 3.8500010 0 3.8600000 0 \
    3.8600010 -1.19182907e-09 3.8700000 -1.19182907e-09 3.8700010 1.32603873e-09 3.8800000 1.32603873e-09 \
    3.8800010 0 3.8900000 0 3.8900010 -1.21563598e-09 3.9000000 -1.21563598e-09 \
    3.9000010 9.39170268e-10 3.9100000 9.39170268e-10 3.9100010 -9.31452693e-10 3.9200000 -9.31452693e-10 \
    3.9200010 2.06985246e-10 3.9300000 2.06985246e-10 3.9300010 1.45567304e-09 3.9400000 1.45567304e-09 \
    3.9400010 0 3.9600000 0 3.9600010 -1.19270349e-09 3.9700000 -1.19270349e-09 \
    3.9700010 1.8764281e-10 3.9800000 1.8764281e-10 3.9800010 1.45420453e-09 3.9900000 1.45420453e-09 \
    3.9900010 -1.01584851e-09 4.0000000 -1.01584851e-09 4.0000010 1.37878963e-09 4.0100000 1.37878963e-09 \
    4.0100010 0 4.0600000 0 ]
Rsh8 (n_ig8 0) resistor r=1G

X9 (n_in 0 n_ig9 n_rm9) ecfet_v3 Rinit=1642.09131525 A_stdp=0
ig9 (0 n_ig9) isource type=pwl wave=[ 0.0000000 0 0.0100000 0 0.0100010 1.47976145e-09 0.0200000 1.47976145e-09 \
    0.0200010 0 0.0600000 0 0.0600010 -1.09877337e-09 0.0700000 -1.09877337e-09 \
    0.0700010 0 0.0800000 0 0.0800010 -2.75742148e-10 0.0900000 -2.75742148e-10 \
    0.0900010 1.26563152e-09 0.1000000 1.26563152e-09 0.1000010 -9.03093861e-10 0.1100000 -9.03093861e-10 \
    0.1100010 3.08749222e-11 0.1200000 3.08749222e-11 0.1200010 1.36948109e-09 0.1300000 1.36948109e-09 \
    0.1300010 1.69157336e-10 0.1400000 1.69157336e-10 0.1400010 -1.03851015e-09 0.1500000 -1.03851015e-09 \
    0.1500010 1.43306549e-09 0.1600000 1.43306549e-09 0.1600010 0 0.2000000 0 \
    0.2000010 -1.07229725e-09 0.2100000 -1.07229725e-09 0.2100010 7.50306104e-10 0.2200000 7.50306104e-10 \
    0.2200010 0 0.2400000 0 0.2400010 5.26460647e-10 0.2500000 5.26460647e-10 \
    0.2500010 -9.80585114e-10 0.2600000 -9.80585114e-10 0.2600010 1.10562391e-09 0.2700000 1.10562391e-09 \
    0.2700010 0 0.3000000 0 0.3000010 -1.26620668e-09 0.3100000 -1.26620668e-09 \
    0.3100010 1.51679691e-11 0.3200000 1.51679691e-11 0.3200010 0 0.3300000 0 \
    0.3300010 5.32736374e-10 0.3400000 5.32736374e-10 0.3400010 0 0.3500000 0 \
    0.3500010 -9.57566702e-10 0.3600000 -9.57566702e-10 0.3600010 7.42027299e-10 0.3700000 7.42027299e-10 \
    0.3700010 0 0.4000000 0 0.4000010 -1.11159211e-09 0.4100000 -1.11159211e-09 \
    0.4100010 0 0.4200000 0 0.4200010 6.61636026e-10 0.4300000 6.61636026e-10 \
    0.4300010 0 0.4500000 0 0.4500010 6.37448456e-10 0.4600000 6.37448456e-10 \
    0.4600010 0 0.5000000 0 0.5000010 4.9063081e-10 0.5100000 4.9063081e-10 \
    0.5100010 -1.09781228e-09 0.5200000 -1.09781228e-09 0.5200010 9.81208883e-10 0.5300000 9.81208883e-10 \
    0.5300010 0 0.5400000 0 0.5400010 -1.06191317e-09 0.5500000 -1.06191317e-09 \
    0.5500010 -2.6672593e-10 0.5600000 -2.6672593e-10 0.5600010 0 0.5800000 0 \
    0.5800010 3.42062055e-10 0.5900000 3.42062055e-10 0.5900010 0 0.6000000 0 \
    0.6000010 -1.07716783e-09 0.6100000 -1.07716783e-09 0.6100010 1.12750236e-09 0.6200000 1.12750236e-09 \
    0.6200010 -1.23816541e-09 0.6300000 -1.23816541e-09 0.6300010 0 0.6400000 0 \
    0.6400010 4.56521995e-10 0.6500000 4.56521995e-10 0.6500010 -1.04434955e-09 0.6600000 -1.04434955e-09 \
    0.6600010 0 0.6700000 0 0.6700010 4.41475815e-10 0.6800000 4.41475815e-10 \
    0.6800010 0 0.6900000 0 0.6900010 6.77944294e-10 0.7000000 6.77944294e-10 \
    0.7000010 -9.31360555e-10 0.7100000 -9.31360555e-10 0.7100010 8.13026166e-10 0.7200000 8.13026166e-10 \
    0.7200010 0 0.7500000 0 0.7500010 -8.15277065e-10 0.7600000 -8.15277065e-10 \
    0.7600010 0 0.7700000 0 0.7700010 3.65884024e-10 0.7800000 3.65884024e-10 \
    0.7800010 0 0.7900000 0 0.7900010 -1.24956914e-09 0.8000000 -1.24956914e-09 \
    0.8000010 0 0.8100000 0 0.8100010 6.29252103e-10 0.8200000 6.29252103e-10 \
    0.8200010 0 0.8400000 0 0.8400010 -1.22419919e-09 0.8500000 -1.22419919e-09 \
    0.8500010 0 0.8700000 0 0.8700010 5.65287797e-10 0.8800000 5.65287797e-10 \
    0.8800010 0 0.8900000 0 0.8900010 3.34213863e-10 0.9000000 3.34213863e-10 \
    0.9000010 -1.1066598e-09 0.9100000 -1.1066598e-09 0.9100010 9.42818902e-10 0.9200000 9.42818902e-10 \
    0.9200010 0 0.9500000 0 0.9500010 1.61705832e-10 0.9600000 1.61705832e-10 \
    0.9600010 0 1.0000000 0 1.0000010 -1.24100662e-09 1.0100000 -1.24100662e-09 \
    1.0100010 8.59150289e-10 1.0200000 8.59150289e-10 1.0200010 0 1.0500000 0 \
    1.0500010 -1.05290561e-09 1.0600000 -1.05290561e-09 1.0600010 9.52862189e-10 1.0700000 9.52862189e-10 \
    1.0700010 0 1.1000000 0 1.1000010 -1.14634808e-09 1.1100000 -1.14634808e-09 \
    1.1100010 7.48057739e-10 1.1200000 7.48057739e-10 1.1200010 0 1.1300000 0 \
    1.1300010 -1.06897275e-09 1.1400000 -1.06897275e-09 1.1400010 7.50513548e-10 1.1500000 7.50513548e-10 \
    1.1500010 3.66533006e-10 1.1600000 3.66533006e-10 1.1600010 0 1.2000000 0 \
    1.2000010 -1.21915543e-09 1.2100000 -1.21915543e-09 1.2100010 7.81039882e-10 1.2200000 7.81039882e-10 \
    1.2200010 0 1.2500000 0 1.2500010 6.48768501e-10 1.2600000 6.48768501e-10 \
    1.2600010 0 1.3000000 0 1.3000010 1.365992e-10 1.3100000 1.365992e-10 \
    1.3100010 0 1.3500000 0 1.3500010 -1.11779409e-09 1.3600000 -1.11779409e-09 \
    1.3600010 -2.87508045e-10 1.3700000 -2.87508045e-10 1.3700010 8.90515147e-10 1.3800000 8.90515147e-10 \
    1.3800010 -1.14821259e-09 1.3900000 -1.14821259e-09 1.3900010 1.21222911e-09 1.4000000 1.21222911e-09 \
    1.4000010 2.82327137e-10 1.4100000 2.82327137e-10 1.4100010 3.52659371e-10 1.4200000 3.52659371e-10 \
    1.4200010 0 1.4300000 0 1.4300010 -1.13211275e-09 1.4400000 -1.13211275e-09 \
    1.4400010 -2.57162281e-10 1.4500000 -2.57162281e-10 1.4500010 1.04289982e-10 1.4600000 1.04289982e-10 \
    1.4600010 0 1.4700000 0 1.4700010 6.35781228e-10 1.4800000 6.35781228e-10 \
    1.4800010 0 1.5000000 0 1.5000010 -1.14274969e-09 1.5100000 -1.14274969e-09 \
    1.5100010 1.16247957e-09 1.5200000 1.16247957e-09 1.5200010 0 1.5500000 0 \
    1.5500010 -1.26806774e-09 1.5600000 -1.26806774e-09 1.5600010 9.58837829e-10 1.5700000 9.58837829e-10 \
    1.5700010 0 1.6100000 0 1.6100010 6.62020388e-11 1.6200000 6.62020388e-11 \
    1.6200010 -1.01486354e-09 1.6300000 -1.01486354e-09 1.6300010 9.27133629e-10 1.6400000 9.27133629e-10 \
    1.6400010 0 1.6500000 0 1.6500010 -1.06302752e-09 1.6600000 -1.06302752e-09 \
    1.6600010 1.4219531e-09 1.6700000 1.4219531e-09 1.6700010 0 1.7100000 0 \
    1.7100010 -1.0864476e-09 1.7200000 -1.0864476e-09 1.7200010 6.29782009e-10 1.7300000 6.29782009e-10 \
    1.7300010 0 1.7600000 0 1.7600010 -1.28641739e-09 1.7700000 -1.28641739e-09 \
    1.7700010 6.49056669e-10 1.7800000 6.49056669e-10 1.7800010 0 1.8100000 0 \
    1.8100010 -7.4157918e-11 1.8200000 -7.4157918e-11 1.8200010 0 1.8300000 0 \
    1.8300010 -1.4351544e-10 1.8400000 -1.4351544e-10 1.8400010 0 1.8600000 0 \
    1.8600010 2.69017147e-10 1.8700000 2.69017147e-10 1.8700010 0 1.9100000 0 \
    1.9100010 -1.05725269e-09 1.9200000 -1.05725269e-09 1.9200010 7.05946034e-10 1.9300000 7.05946034e-10 \
    1.9300010 0 1.9600000 0 1.9600010 -1.03012436e-09 1.9700000 -1.03012436e-09 \
    1.9700010 -2.9277127e-10 1.9800000 -2.9277127e-10 1.9800010 9.26524115e-10 1.9900000 9.26524115e-10 \
    1.9900010 3.3902578e-10 2.0000000 3.3902578e-10 2.0000010 -1.19447933e-09 2.0100000 -1.19447933e-09 \
    2.0100010 0 2.0200000 0 2.0200010 6.22526823e-10 2.0300000 6.22526823e-10 \
    2.0300010 0 2.0500000 0 2.0500010 5.12142156e-10 2.0600000 5.12142156e-10 \
    2.0600010 -1.17872165e-09 2.0700000 -1.17872165e-09 2.0700010 9.87275703e-10 2.0800000 9.87275703e-10 \
    2.0800010 0 2.1000000 0 2.1000010 -1.1934083e-09 2.1100000 -1.1934083e-09 \
    2.1100010 1.0257184e-09 2.1200000 1.0257184e-09 2.1200010 0 2.1500000 0 \
    2.1500010 4.43704402e-10 2.1600000 4.43704402e-10 2.1600010 0 2.1700000 0 \
    2.1700010 -6.22317216e-10 2.1800000 -6.22317216e-10 2.1800010 8.48778628e-10 2.1900000 8.48778628e-10 \
    2.1900010 6.18380045e-11 2.2000000 6.18380045e-11 2.2000010 -1.43875394e-09 2.2100000 -1.43875394e-09 \
    2.2100010 0 2.2200000 0 2.2200010 -6.73558472e-10 2.2300000 -6.73558472e-10 \
    2.2300010 0 2.2400000 0 2.2400010 1.0202226e-09 2.2500000 1.0202226e-09 \
    2.2500010 -1.20512003e-09 2.2600000 -1.20512003e-09 2.2600010 0 2.2700000 0 \
    2.2700010 7.43147041e-10 2.2800000 7.43147041e-10 2.2800010 0 2.2900000 0 \
    2.2900010 -1.12099562e-09 2.3000000 -1.12099562e-09 2.3000010 -5.70576604e-10 2.3100000 -5.70576604e-10 \
    2.3100010 0 2.3200000 0 2.3200010 4.25111983e-10 2.3300000 4.25111983e-10 \
    2.3300010 0 2.3400000 0 2.3400010 -4.74116495e-10 2.3500000 -4.74116495e-10 \
    2.3500010 -4.04397585e-10 2.3600000 -4.04397585e-10 2.3600010 -3.98270404e-10 2.3700000 -3.98270404e-10 \
    2.3700010 8.2967493e-10 2.3800000 8.2967493e-10 2.3800010 0 2.4000000 0 \
    2.4000010 1.87033296e-10 2.4100000 1.87033296e-10 2.4100010 -9.43718015e-10 2.4200000 -9.43718015e-10 \
    2.4200010 2.57791589e-11 2.4300000 2.57791589e-11 2.4300010 1.84361497e-10 2.4400000 1.84361497e-10 \
    2.4400010 -5.88871412e-11 2.4500000 -5.88871412e-11 2.4500010 1.08367672e-09 2.4600000 1.08367672e-09 \
    2.4600010 0 2.4700000 0 2.4700010 -1.06449675e-09 2.4800000 -1.06449675e-09 \
    2.4800010 1.15032715e-09 2.4900000 1.15032715e-09 2.4900010 -1.23802127e-09 2.5000000 -1.23802127e-09 \
    2.5000010 9.55242901e-10 2.5100000 9.55242901e-10 2.5100010 3.46280735e-10 2.5200000 3.46280735e-10 \
    2.5200010 0 2.5500000 0 2.5500010 2.71802436e-10 2.5600000 2.71802436e-10 \
    2.5600010 0 2.5700000 0 2.5700010 6.9855366e-10 2.5800000 6.9855366e-10 \
    2.5800010 0 2.6000000 0 2.6000010 -1.28578952e-09 2.6100000 -1.28578952e-09 \
    2.6100010 1.07755699e-09 2.6200000 1.07755699e-09 2.6200010 5.58680261e-10 2.6300000 5.58680261e-10 \
    2.6300010 0 2.6500000 0 2.6500010 -1.0887373e-09 2.6600000 -1.0887373e-09 \
    2.6600010 8.39069203e-10 2.6700000 8.39069203e-10 2.6700010 -1.02427068e-09 2.6800000 -1.02427068e-09 \
    2.6800010 1.08161276e-09 2.6900000 1.08161276e-09 2.6900010 0 2.7200000 0 \
    2.7200010 3.88759918e-10 2.7300000 3.88759918e-10 2.7300010 0 2.7700000 0 \
    2.7700010 -1.21202056e-09 2.7800000 -1.21202056e-09 2.7800010 6.37857198e-10 2.7900000 6.37857198e-10 \
    2.7900010 0 2.8200000 0 2.8200010 3.0299648e-10 2.8300000 3.0299648e-10 \
    2.8300010 -1.20976018e-09 2.8400000 -1.20976018e-09 2.8400010 8.57075168e-10 2.8500000 8.57075168e-10 \
    2.8500010 0 2.8700000 0 2.8700010 -1.03070864e-09 2.8800000 -1.03070864e-09 \
    2.8800010 1.01238915e-09 2.8900000 1.01238915e-09 2.8900010 0 2.9200000 0 \
    2.9200010 -9.03915621e-10 2.9300000 -9.03915621e-10 2.9300010 0 2.9400000 0 \
    2.9400010 6.14910387e-10 2.9500000 6.14910387e-10 2.9500010 0 2.9700000 0 \
    2.9700010 4.95697841e-10 2.9800000 4.95697841e-10 2.9800010 -1.15162954e-09 2.9900000 -1.15162954e-09 \
    2.9900010 7.91346361e-10 3.0000000 7.91346361e-10 3.0000010 0 3.0200000 0 \
    3.0200010 3.51464367e-10 3.0300000 3.51464367e-10 3.0300010 0 3.0400000 0 \
    3.0400010 -1.21789302e-09 3.0500000 -1.21789302e-09 3.0500010 2.02528659e-10 3.0600000 2.02528659e-10 \
    3.0600010 1.12757066e-09 3.0700000 1.12757066e-09 3.0700010 -1.23073138e-09 3.0800000 -1.23073138e-09 \
    3.0800010 1.27430162e-09 3.0900000 1.27430162e-09 3.0900010 0 3.1100000 0 \
    3.1100010 -1.17138934e-09 3.1200000 -1.17138934e-09 3.1200010 9.53444181e-10 3.1300000 9.53444181e-10 \
    3.1300010 0 3.1400000 0 3.1400010 -1.27241076e-09 3.1500000 -1.27241076e-09 \
    3.1500010 7.34119096e-10 3.1600000 7.34119096e-10 3.1600010 4.33320923e-10 3.1700000 4.33320923e-10 \
    3.1700010 0 3.1800000 0 3.1800010 -1.15286005e-09 3.1900000 -1.15286005e-09 \
    3.1900010 7.66497651e-10 3.2000000 7.66497651e-10 3.2000010 0 3.2300000 0 \
    3.2300010 -1.22003181e-09 3.2400000 -1.22003181e-09 3.2400010 7.13297832e-10 3.2500000 7.13297832e-10 \
    3.2500010 0 3.2800000 0 3.2800010 -1.02374379e-09 3.2900000 -1.02374379e-09 \
    3.2900010 8.13646791e-10 3.3000000 8.13646791e-10 3.3000010 0 3.3300000 0 \
    3.3300010 -1.06939268e-09 3.3400000 -1.06939268e-09 3.3400010 1.17191967e-09 3.3500000 1.17191967e-09 \
    3.3500010 0 3.3800000 0 3.3800010 -1.20432666e-09 3.3900000 -1.20432666e-09 \
    3.3900010 6.89774677e-10 3.4000000 6.89774677e-10 3.4000010 0 3.4300000 0 \
    3.4300010 -9.50447916e-10 3.4400000 -9.50447916e-10 3.4400010 1.40552733e-09 3.4500000 1.40552733e-09 \
    3.4500010 -1.0957685e-09 3.4600000 -1.0957685e-09 3.4600010 7.57950843e-10 3.4700000 7.57950843e-10 \
    3.4700010 4.74950822e-10 3.4800000 4.74950822e-10 3.4800010 4.93870548e-10 3.4900000 4.93870548e-10 \
    3.4900010 -9.70695951e-10 3.5000000 -9.70695951e-10 3.5000010 1.66794177e-10 3.5100000 1.66794177e-10 \
    3.5100010 1.09637504e-09 3.5200000 1.09637504e-09 3.5200010 0 3.5400000 0 \
    3.5400010 -1.13075603e-09 3.5500000 -1.13075603e-09 3.5500010 -2.60295507e-11 3.5600000 -2.60295507e-11 \
    3.5600010 0 3.5700000 0 3.5700010 -3.63449459e-10 3.5800000 -3.63449459e-10 \
    3.5800010 -1.9225516e-10 3.5900000 -1.9225516e-10 3.5900010 7.41082689e-10 3.6000000 7.41082689e-10 \
    3.6000010 -1.35049946e-10 3.6100000 -1.35049946e-10 3.6100010 -1.11274941e-09 3.6200000 -1.11274941e-09 \
    3.6200010 8.39355258e-10 3.6300000 8.39355258e-10 3.6300010 0 3.6400000 0 \
    3.6400010 -1.13546839e-09 3.6500000 -1.13546839e-09 3.6500010 1.27438265e-09 3.6600000 1.27438265e-09 \
    3.6600010 -7.33384337e-10 3.6700000 -7.33384337e-10 3.6700010 1.6952785e-10 3.6800000 1.6952785e-10 \
    3.6800010 1.03992e-10 3.6900000 1.03992e-10 3.6900010 1.93998596e-10 3.7000000 1.93998596e-10 \
    3.7000010 0 3.7100000 0 3.7100010 1.30881177e-09 3.7200000 1.30881177e-09 \
    3.7200010 0 3.7300000 0 3.7300010 3.4799919e-10 3.7400000 3.4799919e-10 \
    3.7400010 3.99596033e-10 3.7500000 3.99596033e-10 3.7500010 -2.11187888e-10 3.7600000 -2.11187888e-10 \
    3.7600010 -1.20513445e-09 3.7700000 -1.20513445e-09 3.7700010 1.41221275e-09 3.7800000 1.41221275e-09 \
    3.7800010 -1.23929743e-09 3.7900000 -1.23929743e-09 3.7900010 1.46351135e-09 3.8000000 1.46351135e-09 \
    3.8000010 0 3.8200000 0 3.8200010 -1.24446375e-09 3.8300000 -1.24446375e-09 \
    3.8300010 0 3.8400000 0 3.8400010 6.90960141e-10 3.8500000 6.90960141e-10 \
    3.8500010 0 3.8700000 0 3.8700010 -1.04996323e-09 3.8800000 -1.04996323e-09 \
    3.8800010 9.81314862e-10 3.8900000 9.81314862e-10 3.8900010 0 3.9200000 0 \
    3.9200010 -1.10223781e-09 3.9300000 -1.10223781e-09 3.9300010 9.67545843e-10 3.9400000 9.67545843e-10 \
    3.9400010 0 3.9700000 0 3.9700010 -1.08950528e-09 3.9800000 -1.08950528e-09 \
    3.9800010 -2.43126748e-10 3.9900000 -2.43126748e-10 3.9900010 -3.69351125e-11 4.0000000 -3.69351125e-11 \
    4.0000010 3.23443343e-10 4.0100000 3.23443343e-10 4.0100010 0 4.0600000 0 ]
Rsh9 (n_ig9 0) resistor r=1G

X10 (n_in 0 n_ig10 n_rm10) ecfet_v3 Rinit=1642.09131525 A_stdp=0
ig10 (0 n_ig10) isource type=pwl wave=[ 0.0000000 0 0.0300000 0 0.0300010 -6.55393653e-10 0.0400000 -6.55393653e-10 \
    0.0400010 5.48576769e-10 0.0500000 5.48576769e-10 0.0500010 -1.22151881e-09 0.0600000 -1.22151881e-09 \
    0.0600010 7.03136396e-10 0.0700000 7.03136396e-10 0.0700010 0 0.0900000 0 \
    0.0900010 -1.22572483e-09 0.1000000 -1.22572483e-09 0.1000010 0 0.1100000 0 \
    0.1100010 8.05424288e-10 0.1200000 8.05424288e-10 0.1200010 0 0.1500000 0 \
    0.1500010 3.12150488e-11 0.1600000 3.12150488e-11 0.1600010 0 0.2000000 0 \
    0.2000010 -1.26893698e-09 0.2100000 -1.26893698e-09 0.2100010 5.35246075e-10 0.2200000 5.35246075e-10 \
    0.2200010 -1.0576454e-09 0.2300000 -1.0576454e-09 0.2300010 1.11880253e-09 0.2400000 1.11880253e-09 \
    0.2400010 2.38167904e-10 0.2500000 2.38167904e-10 0.2500010 0 0.2600000 0 \
    0.2600010 -1.11973008e-09 0.2700000 -1.11973008e-09 0.2700010 9.0457431e-10 0.2800000 9.0457431e-10 \
    0.2800010 3.2421674e-10 0.2900000 3.2421674e-10 0.2900010 -1.25778533e-09 0.3000000 -1.25778533e-09 \
    0.3000010 5.92153872e-10 0.3100000 5.92153872e-10 0.3100010 -1.19548269e-09 0.3200000 -1.19548269e-09 \
    0.3200010 0 0.3300000 0 0.3300010 6.17790897e-10 0.3400000 6.17790897e-10 \
    0.3400010 2.97263785e-10 0.3500000 2.97263785e-10 0.3500010 0 0.3600000 0 \
    0.3600010 8.35025585e-10 0.3700000 8.35025585e-10 0.3700010 0 0.4100000 0 \
    0.4100010 -7.8067896e-10 0.4200000 -7.8067896e-10 0.4200010 1.34424563e-09 0.4300000 1.34424563e-09 \
    0.4300010 0 0.4600000 0 0.4600010 -9.34847497e-10 0.4700000 -9.34847497e-10 \
    0.4700010 8.71876808e-10 0.4800000 8.71876808e-10 0.4800010 0 0.5100000 0 \
    0.5100010 -1.13772462e-09 0.5200000 -1.13772462e-09 0.5200010 1.35866126e-09 0.5300000 1.35866126e-09 \
    0.5300010 0 0.5600000 0 0.5600010 -8.22248508e-10 0.5700000 -8.22248508e-10 \
    0.5700010 0 0.5800000 0 0.5800010 7.21740013e-10 0.5900000 7.21740013e-10 \
    0.5900010 0 0.6100000 0 0.6100010 -1.11629975e-09 0.6200000 -1.11629975e-09 \
    0.6200010 8.52474247e-10 0.6300000 8.52474247e-10 0.6300010 0 0.6400000 0 \
    0.6400010 6.5068358e-12 0.6500000 6.5068358e-12 0.6500010 0 0.6900000 0 \
    0.6900010 3.23535057e-10 0.7000000 3.23535057e-10 0.7000010 -9.45446545e-10 0.7100000 -9.45446545e-10 \
    0.7100010 7.88909966e-10 0.7200000 7.88909966e-10 0.7200010 0 0.7400000 0 \
    0.7400010 -1.29691302e-09 0.7500000 -1.29691302e-09 0.7500010 0 0.7700000 0 \
    0.7700010 1.44189011e-10 0.7800000 1.44189011e-10 0.7800010 0 0.7900000 0 \
    0.7900010 2.08517476e-10 0.8000000 2.08517476e-10 0.8000010 0 0.8400000 0 \
    0.8400010 3.25623208e-10 0.8500000 3.25623208e-10 0.8500010 0 0.8600000 0 \
    0.8600010 -7.01803245e-10 0.8700000 -7.01803245e-10 0.8700010 1.15765172e-09 0.8800000 1.15765172e-09 \
    0.8800010 0 0.8900000 0 0.8900010 -1.71645881e-10 0.9000000 -1.71645881e-10 \
    0.9000010 0 0.9400000 0 0.9400010 7.39994332e-11 0.9500000 7.39994332e-11 \
    0.9500010 -1.2781724e-09 0.9600000 -1.2781724e-09 0.9600010 0 0.9700000 0 \
    0.9700010 1.07014073e-09 0.9800000 1.07014073e-09 0.9800010 0 0.9900000 0 \
    0.9900010 3.33713308e-10 1.0000000 3.33713308e-10 1.0000010 0 1.0400000 0 \
    1.0400010 -2.20394395e-11 1.0500000 -2.20394395e-11 1.0500010 0 1.0700000 0 \
    1.0700010 -1.06908994e-09 1.0800000 -1.06908994e-09 1.0800010 8.45210261e-10 1.0900000 8.45210261e-10 \
    1.0900010 0 1.1200000 0 1.1200010 -1.27800223e-09 1.1300000 -1.27800223e-09 \
    1.1300010 0 1.1400000 0 1.1400010 9.11525786e-10 1.1500000 9.11525786e-10 \
    1.1500010 -1.20824564e-09 1.1600000 -1.20824564e-09 1.1600010 0 1.1700000 0 \
    1.1700010 1.39003624e-09 1.1800000 1.39003624e-09 1.1800010 -1.06179177e-09 1.1900000 -1.06179177e-09 \
    1.1900010 -1.84907447e-10 1.2000000 -1.84907447e-10 1.2000010 1.38844334e-09 1.2100000 1.38844334e-09 \
    1.2100010 -6.85830416e-10 1.2200000 -6.85830416e-10 1.2200010 0 1.2300000 0 \
    1.2300010 1.4445966e-09 1.2400000 1.4445966e-09 1.2400010 -8.68972825e-10 1.2500000 -8.68972825e-10 \
    1.2500010 -2.02321573e-10 1.2600000 -2.02321573e-10 1.2600010 -1.36414302e-10 1.2700000 -1.36414302e-10 \
    1.2700010 -6.22750504e-11 1.2800000 -6.22750504e-11 1.2800010 0 1.2900000 0 \
    1.2900010 2.42842318e-10 1.3000000 2.42842318e-10 1.3000010 7.65849797e-10 1.3100000 7.65849797e-10 \
    1.3100010 -9.98742308e-10 1.3200000 -9.98742308e-10 1.3200010 9.29323043e-10 1.3300000 9.29323043e-10 \
    1.3300010 0 1.3400000 0 1.3400010 3.52055222e-10 1.3500000 3.52055222e-10 \
    1.3500010 -1.12982237e-09 1.3600000 -1.12982237e-09 1.3600010 9.48556819e-10 1.3700000 9.48556819e-10 \
    1.3700010 3.95984634e-10 1.3800000 3.95984634e-10 1.3800010 0 1.3900000 0 \
    1.3900010 -1.24334777e-09 1.4000000 -1.24334777e-09 1.4000010 -3.3608141e-10 1.4100000 -3.3608141e-10 \
    1.4100010 2.17772918e-10 1.4200000 2.17772918e-10 1.4200010 0 1.4300000 0 \
    1.4300010 1.37146826e-09 1.4400000 1.37146826e-09 1.4400010 5.71340036e-10 1.4500000 5.71340036e-10 \
    1.4500010 0 1.4600000 0 1.4600010 -8.20807772e-10 1.4700000 -8.20807772e-10 \
    1.4700010 1.25985801e-09 1.4800000 1.25985801e-09 1.4800010 5.73838366e-10 1.4900000 5.73838366e-10 \
    1.4900010 0 1.5100000 0 1.5100010 -1.17507169e-09 1.5200000 -1.17507169e-09 \
    1.5200010 1.35162947e-09 1.5300000 1.35162947e-09 1.5300010 0 1.5400000 0 \
    1.5400010 -6.8329172e-10 1.5500000 -6.8329172e-10 1.5500010 1.36658332e-10 1.5600000 1.36658332e-10 \
    1.5600010 8.5039377e-10 1.5700000 8.5039377e-10 1.5700010 0 1.5900000 0 \
    1.5900010 4.12026311e-10 1.6000000 4.12026311e-10 1.6000010 -1.22240139e-09 1.6100000 -1.22240139e-09 \
    1.6100010 3.03828977e-10 1.6200000 3.03828977e-10 1.6200010 0 1.6300000 0 \
    1.6300010 3.01181497e-10 1.6400000 3.01181497e-10 1.6400010 9.83539331e-10 1.6500000 9.83539331e-10 \
    1.6500010 -9.41103315e-10 1.6600000 -9.41103315e-10 1.6600010 -1.61083165e-10 1.6700000 -1.61083165e-10 \
    1.6700010 0 1.6800000 0 1.6800010 4.70338908e-10 1.6900000 4.70338908e-10 \
    1.6900010 0 1.7000000 0 1.7000010 -1.27229625e-09 1.7100000 -1.27229625e-09 \
    1.7100010 0 1.7200000 0 1.7200010 4.58799691e-10 1.7300000 4.58799691e-10 \
    1.7300010 -8.69796334e-10 1.7400000 -8.69796334e-10 1.7400010 1.29378344e-09 1.7500000 1.29378344e-09 \
    1.7500010 3.93082285e-10 1.7600000 3.93082285e-10 1.7600010 0 1.7700000 0 \
    1.7700010 4.25451709e-10 1.7800000 4.25451709e-10 1.7800010 0 1.8000000 0 \
    1.8000010 -1.14119673e-09 1.8100000 -1.14119673e-09 1.8100010 6.82200874e-10 1.8200000 6.82200874e-10 \
    1.8200010 0 1.8300000 0 1.8300010 -1.22435871e-09 1.8400000 -1.22435871e-09 \
    1.8400010 0 1.8500000 0 1.8500010 8.45317623e-10 1.8600000 8.45317623e-10 \
    1.8600010 0 1.8800000 0 1.8800010 -9.78128574e-10 1.8900000 -9.78128574e-10 \
    1.8900010 1.31242346e-09 1.9000000 1.31242346e-09 1.9000010 0 1.9400000 0 \
    1.9400010 -1.22890668e-09 1.9500000 -1.22890668e-09 1.9500010 -4.5296763e-10 1.9600000 -4.5296763e-10 \
    1.9600010 0 1.9700000 0 1.9700010 -2.60549923e-10 1.9800000 -2.60549923e-10 \
    1.9800010 1.16771692e-09 1.9900000 1.16771692e-09 1.9900010 0 2.0100000 0 \
    2.0100010 -9.66935199e-10 2.0200000 -9.66935199e-10 2.0200010 9.5118923e-10 2.0300000 9.5118923e-10 \
    2.0300010 -1.05319159e-09 2.0400000 -1.05319159e-09 2.0400010 1.45440783e-09 2.0500000 1.45440783e-09 \
    2.0500010 3.39621893e-10 2.0600000 3.39621893e-10 2.0600010 0 2.0700000 0 \
    2.0700010 4.8276496e-10 2.0800000 4.8276496e-10 2.0800010 0 2.1000000 0 \
    2.1000010 -1.22620436e-09 2.1100000 -1.22620436e-09 2.1100010 -6.44494104e-11 2.1200000 -6.44494104e-11 \
    2.1200010 7.67686019e-12 2.1300000 7.67686019e-12 2.1300010 8.73742891e-10 2.1400000 8.73742891e-10 \
    2.1400010 0 2.1600000 0 2.1600010 -1.04614024e-09 2.1700000 -1.04614024e-09 \
    2.1700010 -1.46722132e-10 2.1800000 -1.46722132e-10 2.1800010 7.57028894e-10 2.1900000 7.57028894e-10 \
    2.1900010 0 2.2000000 0 2.2000010 1.8512906e-10 2.2100000 1.8512906e-10 \
    2.2100010 -9.50336583e-10 2.2200000 -9.50336583e-10 2.2200010 1.48789827e-09 2.2300000 1.48789827e-09 \
    2.2300010 0 2.2700000 0 2.2700010 -1.16262297e-09 2.2800000 -1.16262297e-09 \
    2.2800010 7.31541524e-10 2.2900000 7.31541524e-10 2.2900010 0 2.3200000 0 \
    2.3200010 -1.29878309e-09 2.3300000 -1.29878309e-09 2.3300010 0 2.3400000 0 \
    2.3400010 -2.44472497e-10 2.3500000 -2.44472497e-10 2.3500010 -3.77625772e-10 2.3600000 -3.77625772e-10 \
    2.3600010 -4.5254866e-10 2.3700000 -4.5254866e-10 2.3700010 1.42008437e-09 2.3800000 1.42008437e-09 \
    2.3800010 6.05706169e-10 2.3900000 6.05706169e-10 2.3900010 2.15786236e-10 2.4000000 2.15786236e-10 \
    2.4000010 -3.61175602e-11 2.4100000 -3.61175602e-11 2.4100010 0 2.4500000 0 \
    2.4500010 1.94905096e-10 2.4600000 1.94905096e-10 2.4600010 0 2.5000000 0 \
    2.5000010 3.97620831e-10 2.5100000 3.97620831e-10 2.5100010 0 2.5500000 0 \
    2.5500010 -3.36797668e-11 2.5600000 -3.36797668e-11 2.5600010 0 2.6000000 0 \
    2.6000010 -1.64053455e-10 2.6100000 -1.64053455e-10 2.6100010 0 2.6400000 0 \
    2.6400010 -1.2932286e-09 2.6500000 -1.2932286e-09 2.6500010 -3.07680868e-10 2.6600000 -3.07680868e-10 \
    2.6600010 6.11962077e-10 2.6700000 6.11962077e-10 2.6700010 0 2.7000000 0 \
    2.7000010 7.21609231e-10 2.7100000 7.21609231e-10 2.7100010 0 2.7400000 0 \
    2.7400010 3.80825106e-10 2.7500000 3.80825106e-10 2.7500010 3.50705744e-10 2.7600000 3.50705744e-10 \
    2.7600010 0 2.8000000 0 2.8000010 -6.16483217e-10 2.8100000 -6.16483217e-10 \
    2.8100010 8.30122178e-10 2.8200000 8.30122178e-10 2.8200010 0 2.8300000 0 \
    2.8300010 -1.11622115e-09 2.8400000 -1.11622115e-09 2.8400010 1.39161785e-09 2.8500000 1.39161785e-09 \
    2.8500010 -8.87698268e-10 2.8600000 -8.87698268e-10 2.8600010 6.88546743e-10 2.8700000 6.88546743e-10 \
    2.8700010 0 2.8800000 0 2.8800010 -1.03195431e-09 2.8900000 -1.03195431e-09 \
    2.8900010 2.44569655e-10 2.9000000 2.44569655e-10 2.9000010 0 2.9100000 0 \
    2.9100010 6.59451596e-10 2.9200000 6.59451596e-10 2.9200010 0 2.9300000 0 \
    2.9300010 -6.99893908e-10 2.9400000 -6.99893908e-10 2.9400010 -8.69201521e-11 2.9500000 -8.69201521e-11 \
    2.9500010 8.57351005e-10 2.9600000 8.57351005e-10 2.9600010 4.6641948e-10 2.9700000 4.6641948e-10 \
    2.9700010 -1.05592942e-09 2.9800000 -1.05592942e-09 2.9800010 0 2.9900000 0 \
    2.9900010 1.36117955e-09 3.0000000 1.36117955e-09 3.0000010 -5.99803521e-10 3.0100000 -5.99803521e-10 \
    3.0100010 1.43874783e-09 3.0200000 1.43874783e-09 3.0200010 1.94317194e-10 3.0300000 1.94317194e-10 \
    3.0300010 0 3.0600000 0 3.0600010 3.17885463e-10 3.0700000 3.17885463e-10 \
    3.0700010 -1.1558129e-09 3.0800000 -1.1558129e-09 3.0800010 1.65017236e-11 3.0900000 1.65017236e-11 \
    3.0900010 0 3.1000000 0 3.1000010 6.31790299e-10 3.1100000 6.31790299e-10 \
    3.1100010 0 3.1300000 0 3.1300010 -9.51800094e-10 3.1400000 -9.51800094e-10 \
    3.1400010 1.24570271e-09 3.1500000 1.24570271e-09 3.1500010 2.37149471e-10 3.1600000 2.37149471e-10 \
    3.1600010 0 3.1700000 0 3.1700010 -9.23286731e-10 3.1800000 -9.23286731e-10 \
    3.1800010 1.55060785e-10 3.1900000 1.55060785e-10 3.1900010 1.27033912e-09 3.2000000 1.27033912e-09 \
    3.2000010 0 3.2200000 0 3.2200010 -1.27118366e-09 3.2300000 -1.27118366e-09 \
    3.2300010 7.05523489e-10 3.2400000 7.05523489e-10 3.2400010 -1.53787368e-11 3.2500000 -1.53787368e-11 \
    3.2500010 0 3.2700000 0 3.2700010 -1.19758538e-10 3.2800000 -1.19758538e-10 \
    3.2800010 0 3.3200000 0 3.3200010 1.6458287e-10 3.3300000 1.6458287e-10 \
    3.3300010 0 3.3700000 0 3.3700010 -1.2923915e-09 3.3800000 -1.2923915e-09 \
    3.3800010 7.11529188e-10 3.3900000 7.11529188e-10 3.3900010 0 3.4200000 0 \
    3.4200010 1.51331881e-10 3.4300000 1.51331881e-10 3.4300010 0 3.4700000 0 \
    3.4700010 4.1994354e-10 3.4800000 4.1994354e-10 3.4800010 -4.51085538e-11 3.4900000 -4.51085538e-11 \
    3.4900010 0 3.5000000 0 3.5000010 -1.15498044e-09 3.5100000 -1.15498044e-09 \
    3.5100010 9.184334e-10 3.5200000 9.184334e-10 3.5200010 0 3.5300000 0 \
    3.5300010 2.33665228e-10 3.5400000 2.33665228e-10 3.5400010 0 3.5800000 0 \
    3.5800010 3.62471385e-10 3.5900000 3.62471385e-10 3.5900010 0 3.6300000 0 \
    3.6300010 -9.76803083e-11 3.6400000 -9.76803083e-11 3.6400010 0 3.6800000 0 \
    3.6800010 3.02348906e-10 3.6900000 3.02348906e-10 3.6900010 0 3.7300000 0 \
    3.7300010 3.82853127e-10 3.7400000 3.82853127e-10 3.7400010 0 3.7800000 0 \
    3.7800010 7.26067193e-11 3.7900000 7.26067193e-11 3.7900010 0 3.8200000 0 \
    3.8200010 3.64149403e-11 3.8300000 3.64149403e-11 3.8300010 -1.1608699e-09 3.8400000 -1.1608699e-09 \
    3.8400010 8.26523687e-10 3.8500000 8.26523687e-10 3.8500010 0 3.8800000 0 \
    3.8800010 2.79875269e-10 3.8900000 2.79875269e-10 3.8900010 0 3.9300000 0 \
    3.9300010 1.85265483e-10 3.9400000 1.85265483e-10 3.9400010 0 3.9800000 0 \
    3.9800010 1.51065654e-10 3.9900000 1.51065654e-10 3.9900010 0 4.0600000 0 ]
Rsh10 (n_ig10 0) resistor r=1G

X11 (n_in 0 n_ig11 n_rm11) ecfet_v3 Rinit=1642.09131525 A_stdp=0
ig11 (0 n_ig11) isource type=pwl wave=[ 0.0000000 0 0.0100000 0 0.0100010 9.49471365e-11 0.0200000 9.49471365e-11 \
    0.0200010 0 0.0300000 0 0.0300010 3.72360781e-11 0.0400000 3.72360781e-11 \
    0.0400010 5.78077063e-10 0.0500000 5.78077063e-10 0.0500010 0 0.0700000 0 \
    0.0700010 -8.56015139e-10 0.0800000 -8.56015139e-10 0.0800010 1.24381014e-09 0.0900000 1.24381014e-09 \
    0.0900010 0 0.1100000 0 0.1100010 -1.09735263e-09 0.1200000 -1.09735263e-09 \
    0.1200010 1.67387667e-11 0.1300000 1.67387667e-11 0.1300010 7.47716059e-10 0.1400000 7.47716059e-10 \
    0.1400010 0 0.1700000 0 0.1700010 -7.09376791e-10 0.1800000 -7.09376791e-10 \
    0.1800010 1.71547206e-10 0.1900000 1.71547206e-10 0.1900010 7.60702295e-10 0.2000000 7.60702295e-10 \
    0.2000010 0 0.2200000 0 0.2200010 -9.58652364e-10 0.2300000 -9.58652364e-10 \
    0.2300010 1.30321455e-09 0.2400000 1.30321455e-09 0.2400010 0 0.2700000 0 \
    0.2700010 -1.21236434e-09 0.2800000 -1.21236434e-09 0.2800010 7.22375829e-10 0.2900000 7.22375829e-10 \
    0.2900010 0 0.3200000 0 0.3200010 -9.34600989e-10 0.3300000 -9.34600989e-10 \
    0.3300010 1.01230651e-09 0.3400000 1.01230651e-09 0.3400010 0 0.3600000 0 \
    0.3600010 7.09603054e-10 0.3700000 7.09603054e-10 0.3700010 -1.00278818e-09 0.3800000 -1.00278818e-09 \
    0.3800010 1.09549964e-09 0.3900000 1.09549964e-09 0.3900010 0 0.4200000 0 \
    0.4200010 -1.04730544e-09 0.4300000 -1.04730544e-09 0.4300010 0 0.4400000 0 \
    0.4400010 6.86003172e-10 0.4500000 6.86003172e-10 0.4500010 0 0.4700000 0 \
    0.4700010 7.47078417e-10 0.4800000 7.47078417e-10 0.4800010 0 0.5000000 0 \
    0.5000010 2.65299845e-10 0.5100000 2.65299845e-10 0.5100010 0 0.5200000 0 \
    0.5200010 -1.04184642e-09 0.5300000 -1.04184642e-09 0.5300010 7.99688808e-10 0.5400000 7.99688808e-10 \
    0.5400010 0 0.5700000 0 0.5700010 -6.40197456e-10 0.5800000 -6.40197456e-10 \
    0.5800010 1.19235628e-09 0.5900000 1.19235628e-09 0.5900010 0 0.6100000 0 \
    0.6100010 4.50912823e-10 0.6200000 4.50912823e-10 0.6200010 4.40425974e-10 0.6300000 4.40425974e-10 \
    0.6300010 0 0.6700000 0 0.6700010 -9.81509896e-10 0.6800000 -9.81509896e-10 \
    0.6800010 0 0.6900000 0 0.6900010 5.42008372e-10 0.7000000 5.42008372e-10 \
    0.7000010 0 0.7200000 0 0.7200010 -9.39375972e-10 0.7300000 -9.39375972e-10 \
    0.7300010 0 0.7400000 0 0.7400010 1.23597049e-09 0.7500000 1.23597049e-09 \
    0.7500010 0 0.7700000 0 0.7700010 8.99167195e-10 0.7800000 8.99167195e-10 \
    0.7800010 0 0.8200000 0 0.8200010 -1.2750839e-09 0.8300000 -1.2750839e-09 \
    0.8300010 0 0.8400000 0 0.8400010 5.26936755e-10 0.8500000 5.26936755e-10 \
    0.8500010 0 0.8600000 0 0.8600010 -6.40492501e-10 0.8700000 -6.40492501e-10 \
    0.8700010 1.39064693e-09 0.8800000 1.39064693e-09 0.8800010 0 0.9100000 0 \
    0.9100010 -1.20518897e-09 0.9200000 -1.20518897e-09 0.9200010 7.94558304e-10 0.9300000 7.94558304e-10 \
    0.9300010 -8.85804988e-10 0.9400000 -8.85804988e-10 0.9400010 1.0459279e-09 0.9500000 1.0459279e-09 \
    0.9500010 1.24974031e-10 0.9600000 1.24974031e-10 0.9600010 -1.03089168e-09 0.9700000 -1.03089168e-09 \
    0.9700010 1.07687471e-10 0.9800000 1.07687471e-10 0.9800010 -3.59219575e-10 0.9900000 -3.59219575e-10 \
    0.9900010 1.15459471e-10 1.0000000 1.15459471e-10 1.0000010 1.06988742e-09 1.0100000 1.06988742e-09 \
    1.0100010 -7.69443553e-10 1.0200000 -7.69443553e-10 1.0200010 2.40500764e-10 1.0300000 2.40500764e-10 \
    1.0300010 1.09720693e-09 1.0400000 1.09720693e-09 1.0400010 0 1.0600000 0 \
    1.0600010 -1.03218865e-09 1.0700000 -1.03218865e-09 1.0700010 1.2507213e-09 1.0800000 1.2507213e-09 \
    1.0800010 -1.25978856e-09 1.0900000 -1.25978856e-09 1.0900010 8.04401135e-10 1.1000000 8.04401135e-10 \
    1.1000010 -1.26618952e-09 1.1100000 -1.26618952e-09 1.1100010 1.39035622e-10 1.1200000 1.39035622e-10 \
    1.1200010 1.28105191e-09 1.1300000 1.28105191e-09 1.1300010 -1.15985273e-09 1.1400000 -1.15985273e-09 \
    1.1400010 8.59511411e-11 1.1500000 8.59511411e-11 1.1500010 1.28493958e-09 1.1600000 1.28493958e-09 \
    1.1600010 -8.58842932e-10 1.1700000 -8.58842932e-10 1.1700010 9.85479721e-10 1.1800000 9.85479721e-10 \
    1.1800010 -1.14964582e-09 1.1900000 -1.14964582e-09 1.1900010 -2.30690034e-10 1.2000000 -2.30690034e-10 \
    1.2000010 1.30149797e-09 1.2100000 1.30149797e-09 1.2100010 0 1.2400000 0 \
    1.2400010 -1.08577265e-09 1.2500000 -1.08577265e-09 1.2500010 5.87195677e-11 1.2600000 5.87195677e-11 \
    1.2600010 8.29501453e-10 1.2700000 8.29501453e-10 1.2700010 -1.21458899e-10 1.2800000 -1.21458899e-10 \
    1.2800010 -9.38572368e-10 1.2900000 -9.38572368e-10 1.2900010 -1.8752099e-10 1.3000000 -1.8752099e-10 \
    1.3000010 1.42032999e-09 1.3100000 1.42032999e-09 1.3100010 -1.07287062e-09 1.3200000 -1.07287062e-09 \
    1.3200010 9.59798694e-11 1.3300000 9.59798694e-11 1.3300010 0 1.3400000 0 \
    1.3400010 6.21773141e-10 1.3500000 6.21773141e-10 1.3500010 -1.07092821e-09 1.3600000 -1.07092821e-09 \
    1.3600010 -2.07791503e-10 1.3700000 -2.07791503e-10 1.3700010 5.13699817e-10 1.3800000 5.13699817e-10 \
    1.3800010 -1.24564517e-09 1.3900000 -1.24564517e-09 1.3900010 3.69403096e-10 1.4000000 3.69403096e-10 \
    1.4000010 1.07230581e-10 1.4100000 1.07230581e-10 1.4100010 1.07409017e-09 1.4200000 1.07409017e-09 \
    1.4200010 -9.88998256e-10 1.4300000 -9.88998256e-10 1.4300010 1.18613931e-10 1.4400000 1.18613931e-10 \
    1.4400010 -4.42324088e-10 1.4500000 -4.42324088e-10 1.4500010 3.17545729e-10 1.4600000 3.17545729e-10 \
    1.4600010 0 1.4700000 0 1.4700010 5.95561065e-10 1.4800000 5.95561065e-10 \
    1.4800010 3.69370946e-10 1.4900000 3.69370946e-10 1.4900010 -8.79936713e-10 1.5000000 -8.79936713e-10 \
    1.5000010 1.88305657e-10 1.5100000 1.88305657e-10 1.5100010 9.70136631e-10 1.5200000 9.70136631e-10 \
    1.5200010 -6.16591556e-10 1.5300000 -6.16591556e-10 1.5300010 0 1.5400000 0 \
    1.5400010 8.64909285e-10 1.5500000 8.64909285e-10 1.5500010 0 1.5700000 0 \
    1.5700010 -1.08101041e-09 1.5800000 -1.08101041e-09 1.5800010 -2.46236813e-10 1.5900000 -2.46236813e-10 \
    1.5900010 7.73539695e-10 1.6000000 7.73539695e-10 1.6000010 7.23679047e-11 1.6100000 7.23679047e-11 \
    1.6100010 -7.6013658e-10 1.6200000 -7.6013658e-10 1.6200010 0 1.6300000 0 \
    1.6300010 -5.20849962e-10 1.6400000 -5.20849962e-10 1.6400010 -4.87559947e-12 1.6500000 -4.87559947e-12 \
    1.6500010 0 1.6600000 0 1.6600010 1.48598714e-09 1.6700000 1.48598714e-09 \
    1.6700010 0 1.6800000 0 1.6800010 -6.69422476e-10 1.6900000 -6.69422476e-10 \
    1.6900010 0 1.7000000 0 1.7000010 5.88239347e-10 1.7100000 5.88239347e-10 \
    1.7100010 -9.90184164e-10 1.7200000 -9.90184164e-10 1.7200010 9.6600425e-11 1.7300000 9.6600425e-11 \
    1.7300010 0 1.7400000 0 1.7400010 5.96907324e-10 1.7500000 5.96907324e-10 \
    1.7500010 3.59962921e-10 1.7600000 3.59962921e-10 1.7600010 -1.28185892e-09 1.7700000 -1.28185892e-09 \
    1.7700010 -5.2746818e-10 1.7800000 -5.2746818e-10 1.7800010 9.26924678e-11 1.7900000 9.26924678e-11 \
    1.7900010 0 1.8000000 0 1.8000010 7.35896138e-10 1.8100000 7.35896138e-10 \
    1.8100010 6.16437287e-10 1.8200000 6.16437287e-10 1.8200010 0 1.8300000 0 \
    1.8300010 -6.21119289e-11 1.8400000 -6.21119289e-11 1.8400010 -9.74289102e-10 1.8500000 -9.74289102e-10 \
    1.8500010 1.11335558e-09 1.8600000 1.11335558e-09 1.8600010 -1.21453545e-09 1.8700000 -1.21453545e-09 \
    1.8700010 1.22412052e-09 1.8800000 1.22412052e-09 1.8800010 -9.71894072e-10 1.8900000 -9.71894072e-10 \
    1.8900010 1.20888279e-09 1.9000000 1.20888279e-09 1.9000010 -1.25471254e-09 1.9100000 -1.25471254e-09 \
    1.9100010 0 1.9200000 0 1.9200010 5.00723496e-10 1.9300000 5.00723496e-10 \
    1.9300010 6.78208959e-11 1.9400000 6.78208959e-11 1.9400010 -1.0322766e-09 1.9500000 -1.0322766e-09 \
    1.9500010 9.91443467e-10 1.9600000 9.91443467e-10 1.9600010 -7.99933999e-10 1.9700000 -7.99933999e-10 \
    1.9700010 1.05647455e-10 1.9800000 1.05647455e-10 1.9800010 -4.94913119e-10 1.9900000 -4.94913119e-10 \
    1.9900010 8.67359326e-10 2.0000000 8.67359326e-10 2.0000010 5.32125189e-10 2.0100000 5.32125189e-10 \
    2.0100010 0 2.0400000 0 2.0400010 -1.1331264e-09 2.0500000 -1.1331264e-09 \
    2.0500010 -1.35422616e-10 2.0600000 -1.35422616e-10 2.0600010 1.21622339e-09 2.0700000 1.21622339e-09 \
    2.0700010 0 2.0900000 0 2.0900010 5.96541055e-10 2.1000000 5.96541055e-10 \
    2.1000010 0 2.1100000 0 2.1100010 -1.10566098e-09 2.1200000 -1.10566098e-09 \
    2.1200010 1.12248984e-09 2.1300000 1.12248984e-09 2.1300010 0 2.1400000 0 \
    2.1400010 -8.96654519e-10 2.1500000 -8.96654519e-10 2.1500010 7.03946903e-10 2.1600000 7.03946903e-10 \
    2.1600010 0 2.1800000 0 2.1800010 -1.2217354e-09 2.1900000 -1.2217354e-09 \
    2.1900010 1.32215944e-09 2.2000000 1.32215944e-09 2.2000010 3.65252925e-12 2.2100000 3.65252925e-12 \
    2.2100010 0 2.2400000 0 2.2400010 -4.98298081e-10 2.2500000 -4.98298081e-10 \
    2.2500010 7.56971649e-10 2.2600000 7.56971649e-10 2.2600010 0 2.2900000 0 \
    2.2900010 -9.93401404e-10 2.3000000 -9.93401404e-10 2.3000010 9.01036366e-10 2.3100000 9.01036366e-10 \
    2.3100010 0 2.3400000 0 2.3400010 -1.09773272e-09 2.3500000 -1.09773272e-09 \
    2.3500010 -1.24722574e-10 2.3600000 -1.24722574e-10 2.3600010 7.5047739e-10 2.3700000 7.5047739e-10 \
    2.3700010 0 2.3900000 0 2.3900010 -1.36718614e-09 2.4000000 -1.36718614e-09 \
    2.4000010 1.77993604e-10 2.4100000 1.77993604e-10 2.4100010 0 2.4200000 0 \
    2.4200010 1.4998127e-09 2.4300000 1.4998127e-09 2.4300010 -1.13940365e-09 2.4400000 -1.13940365e-09 \
    2.4400010 1.48245922e-09 2.4500000 1.48245922e-09 2.4500010 -1.24691397e-09 2.4600000 -1.24691397e-09 \
    2.4600010 1.00531257e-09 2.4700000 1.00531257e-09 2.4700010 -9.62880046e-10 2.4800000 -9.62880046e-10 \
    2.4800010 -1.6488416e-10 2.4900000 -1.6488416e-10 2.4900010 8.7514888e-10 2.5000000 8.7514888e-10 \
    2.5000010 -8.37878016e-10 2.5100000 -8.37878016e-10 2.5100010 1.31403877e-09 2.5200000 1.31403877e-09 \
    2.5200010 0 2.5300000 0 2.5300010 6.67668859e-10 2.5400000 6.67668859e-10 \
    2.5400010 0 2.5700000 0 2.5700010 7.13448269e-10 2.5800000 7.13448269e-10 \
    2.5800010 2.5329717e-10 2.5900000 2.5329717e-10 2.5900010 1.70818322e-11 2.6000000 1.70818322e-11 \
    2.6000010 1.92628916e-10 2.6100000 1.92628916e-10 2.6100010 1.70154425e-10 2.6200000 1.70154425e-10 \
    2.6200010 1.46775226e-10 2.6300000 1.46775226e-10 2.6300010 -1.1028251e-09 2.6400000 -1.1028251e-09 \
    2.6400010 1.45794144e-09 2.6500000 1.45794144e-09 2.6500010 -1.04480017e-09 2.6600000 -1.04480017e-09 \
    2.6600010 8.74613183e-10 2.6700000 8.74613183e-10 2.6700010 -1.11766915e-09 2.6800000 -1.11766915e-09 \
    2.6800010 1.40258224e-09 2.6900000 1.40258224e-09 2.6900010 0 2.7000000 0 \
    2.7000010 -4.09901275e-10 2.7100000 -4.09901275e-10 2.7100010 1.04888423e-09 2.7200000 1.04888423e-09 \
    2.7200010 1.01967245e-10 2.7300000 1.01967245e-10 2.7300010 0 2.7700000 0 \
    2.7700010 7.20241825e-10 2.7800000 7.20241825e-10 2.7800010 0 2.8200000 0 \
    2.8200010 5.34663546e-11 2.8300000 5.34663546e-11 2.8300010 0 2.8600000 0 \
    2.8600010 2.59393802e-10 2.8700000 2.59393802e-10 2.8700010 0 2.8800000 0 \
    2.8800010 -1.09431073e-09 2.8900000 -1.09431073e-09 2.8900010 8.92479237e-10 2.9000000 8.92479237e-10 \
    2.9000010 0 2.9100000 0 2.9100010 -1.27006374e-09 2.9200000 -1.27006374e-09 \
    2.9200010 0 2.9400000 0 2.9400010 3.10840377e-10 2.9500000 3.10840377e-10 \
    2.9500010 0 2.9600000 0 2.9600010 4.83043419e-10 2.9700000 4.83043419e-10 \
    2.9700010 4.21038346e-10 2.9800000 4.21038346e-10 2.9800010 0 3.0100000 0 \
    3.0100010 3.30751482e-10 3.0200000 3.30751482e-10 3.0200010 -8.80106653e-11 3.0300000 -8.80106653e-11 \
    3.0300010 0 3.0400000 0 3.0400010 -1.1190413e-09 3.0500000 -1.1190413e-09 \
    3.0500010 9.49863035e-10 3.0600000 9.49863035e-10 3.0600010 0 3.0900000 0 \
    3.0900010 -8.06415737e-10 3.1000000 -8.06415737e-10 3.1000010 9.24266607e-10 3.1100000 9.24266607e-10 \
    3.1100010 0 3.1200000 0 3.1200010 3.55439859e-10 3.1300000 3.55439859e-10 \
    3.1300010 -1.07370653e-09 3.1400000 -1.07370653e-09 3.1400010 9.78189878e-10 3.1500000 9.78189878e-10 \
    3.1500010 3.30954619e-10 3.1600000 3.30954619e-10 3.1600010 -1.4656801e-10 3.1700000 -1.4656801e-10 \
    3.1700010 -1.2165478e-09 3.1800000 -1.2165478e-09 3.1800010 7.08911601e-10 3.1900000 7.08911601e-10 \
    3.1900010 0 3.2100000 0 3.2100010 -1.07845962e-09 3.2200000 -1.07845962e-09 \
    3.2200010 1.39400847e-09 3.2300000 1.39400847e-09 3.2300010 0 3.2400000 0 \
    3.2400010 -2.79043341e-11 3.2500000 -2.79043341e-11 3.2500010 -6.31393481e-11 3.2600000 -6.31393481e-11 \
    3.2600010 5.0201898e-10 3.2700000 5.0201898e-10 3.2700010 6.93665172e-11 3.2800000 6.93665172e-11 \
    3.2800010 0 3.2900000 0 3.2900010 -8.55412254e-10 3.3000000 -8.55412254e-10 \
    3.3000010 0 3.3100000 0 3.3100010 -6.13843993e-10 3.3200000 -6.13843993e-10 \
    3.3200010 -1.32444684e-10 3.3300000 -1.32444684e-10 3.3300010 1.16266079e-09 3.3400000 1.16266079e-09 \
    3.3400010 5.16740874e-10 3.3500000 5.16740874e-10 3.3500010 0 3.3600000 0 \
    3.3600010 -9.77864668e-10 3.3700000 -9.77864668e-10 3.3700010 -3.10948738e-10 3.3800000 -3.10948738e-10 \
    3.3800010 1.38449575e-09 3.3900000 1.38449575e-09 3.3900010 0 3.4300000 0 \
    3.4300010 -1.07252997e-09 3.4400000 -1.07252997e-09 3.4400010 9.02031582e-10 3.4500000 9.02031582e-10 \
    3.4500010 0 3.4600000 0 3.4600010 -1.12696602e-09 3.4700000 -1.12696602e-09 \
    3.4700010 1.25366804e-09 3.4800000 1.25366804e-09 3.4800010 5.59477625e-10 3.4900000 5.59477625e-10 \
    3.4900010 -9.81015503e-10 3.5000000 -9.81015503e-10 3.5000010 1.1793999e-09 3.5100000 1.1793999e-09 \
    3.5100010 -9.66558e-10 3.5200000 -9.66558e-10 3.5200010 0 3.5300000 0 \
    3.5300010 1.28846914e-10 3.5400000 1.28846914e-10 3.5400010 -6.51467137e-11 3.5500000 -6.51467137e-11 \
    3.5500010 1.14279409e-09 3.5600000 1.14279409e-09 3.5600010 0 3.5900000 0 \
    3.5900010 1.33608917e-10 3.6000000 1.33608917e-10 3.6000010 0 3.6100000 0 \
    3.6100010 -8.57973633e-10 3.6200000 -8.57973633e-10 3.6200010 1.26795412e-09 3.6300000 1.26795412e-09 \
    3.6300010 4.93879638e-10 3.6400000 4.93879638e-10 3.6400010 0 3.6600000 0 \
    3.6600010 -7.38113874e-10 3.6700000 -7.38113874e-10 3.6700010 3.56839824e-10 3.6800000 3.56839824e-10 \
    3.6800010 1.44286639e-09 3.6900000 1.44286639e-09 3.6900010 4.51302868e-10 3.7000000 4.51302868e-10 \
    3.7000010 0 3.7100000 0 3.7100010 -1.12467444e-09 3.7200000 -1.12467444e-09 \
    3.7200010 1.44898667e-09 3.7300000 1.44898667e-09 3.7300010 0 3.7400000 0 \
    3.7400010 -1.25617268e-09 3.7500000 -1.25617268e-09 3.7500010 1.47889211e-09 3.7600000 1.47889211e-09 \
    3.7600010 0 3.7700000 0 3.7700010 -1.18969345e-09 3.7800000 -1.18969345e-09 \
    3.7800010 1.47840043e-09 3.7900000 1.47840043e-09 3.7900010 -1.3004446e-10 3.8000000 -1.3004446e-10 \
    3.8000010 -1.02239245e-09 3.8100000 -1.02239245e-09 3.8100010 1.32590164e-09 3.8200000 1.32590164e-09 \
    3.8200010 -1.29205865e-09 3.8300000 -1.29205865e-09 3.8300010 0 3.8400000 0 \
    3.8400010 8.5675884e-10 3.8500000 8.5675884e-10 3.8500010 0 3.8600000 0 \
    3.8600010 -1.12468535e-09 3.8700000 -1.12468535e-09 3.8700010 -1.99567972e-10 3.8800000 -1.99567972e-10 \
    3.8800010 7.98965528e-10 3.8900000 7.98965528e-10 3.8900010 3.91749523e-10 3.9000000 3.91749523e-10 \
    3.9000010 -7.9102974e-10 3.9100000 -7.9102974e-10 3.9100010 0 3.9200000 0 \
    3.9200010 9.4978517e-10 3.9300000 9.4978517e-10 3.9300010 0 3.9400000 0 \
    3.9400010 8.42049216e-11 3.9500000 8.42049216e-11 3.9500010 -1.50983671e-11 3.9600000 -1.50983671e-11 \
    3.9600010 0 3.9800000 0 3.9800010 -1.22754543e-09 3.9900000 -1.22754543e-09 \
    3.9900010 2.25668605e-11 4.0000000 2.25668605e-11 4.0000010 -2.64132761e-10 4.0100000 -2.64132761e-10 \
    4.0100010 0 4.0600000 0 ]
Rsh11 (n_ig11 0) resistor r=1G

X12 (n_in 0 n_ig12 n_rm12) ecfet_v3 Rinit=1642.09131525 A_stdp=0
ig12 (0 n_ig12) isource type=pwl wave=[ 0.0000000 0 0.0100000 0 0.0100010 9.96729987e-10 0.0200000 9.96729987e-10 \
    0.0200010 0 0.0400000 0 0.0400010 4.407988e-10 0.0500000 4.407988e-10 \
    0.0500010 0 0.0600000 0 0.0600010 5.10160957e-10 0.0700000 5.10160957e-10 \
    0.0700010 0 0.1100000 0 0.1100010 -1.28938514e-09 0.1200000 -1.28938514e-09 \
    0.1200010 7.95706966e-10 0.1300000 7.95706966e-10 0.1300010 0 0.1400000 0 \
    0.1400010 -1.01652739e-09 0.1500000 -1.01652739e-09 0.1500010 9.65824868e-10 0.1600000 9.65824868e-10 \
    0.1600010 0 0.1700000 0 0.1700010 -7.94771996e-10 0.1800000 -7.94771996e-10 \
    0.1800010 9.68775161e-10 0.1900000 9.68775161e-10 0.1900010 0 0.2000000 0 \
    0.2000010 -1.05463341e-09 0.2100000 -1.05463341e-09 0.2100010 -1.05355244e-10 0.2200000 -1.05355244e-10 \
    0.2200010 0 0.2300000 0 0.2300010 7.78528676e-10 0.2400000 7.78528676e-10 \
    0.2400010 0 0.2500000 0 0.2500010 -1.11955343e-09 0.2600000 -1.11955343e-09 \
    0.2600010 1.05231778e-09 0.2700000 1.05231778e-09 0.2700010 -1.20772133e-09 0.2800000 -1.20772133e-09 \
    0.2800010 1.44468438e-09 0.2900000 1.44468438e-09 0.2900010 -1.23689835e-09 0.3000000 -1.23689835e-09 \
    0.3000010 8.00973019e-10 0.3100000 8.00973019e-10 0.3100010 0 0.3400000 0 \
    0.3400010 5.93371387e-10 0.3500000 5.93371387e-10 0.3500010 0 0.3900000 0 \
    0.3900010 -8.74332925e-10 0.4000000 -8.74332925e-10 0.4000010 1.07736315e-09 0.4100000 1.07736315e-09 \
    0.4100010 0 0.4400000 0 0.4400010 -1.1264289e-09 0.4500000 -1.1264289e-09 \
    0.4500010 7.25721399e-10 0.4600000 7.25721399e-10 0.4600010 0 0.4700000 0 \
    0.4700010 6.41787837e-10 0.4800000 6.41787837e-10 0.4800010 0 0.4900000 0 \
    0.4900010 6.81208969e-10 0.5000000 6.81208969e-10 0.5000010 5.39062287e-10 0.5100000 5.39062287e-10 \
    0.5100010 0 0.5400000 0 0.5400010 -1.03282189e-09 0.5500000 -1.03282189e-09 \
    0.5500010 9.61352049e-10 0.5600000 9.61352049e-10 0.5600010 0 0.5800000 0 \
    0.5800010 -1.24233645e-09 0.5900000 -1.24233645e-09 0.5900010 0 0.6000000 0 \
    0.6000010 1.10054765e-09 0.6100000 1.10054765e-09 0.6100010 0 0.6400000 0 \
    0.6400010 3.93034905e-10 0.6500000 3.93034905e-10 0.6500010 0 0.6900000 0 \
    0.6900010 -1.26692184e-09 0.7000000 -1.26692184e-09 0.7000010 0 0.7100000 0 \
    0.7100010 4.3857627e-10 0.7200000 4.3857627e-10 0.7200010 0 0.7400000 0 \
    0.7400010 -1.12549866e-09 0.7500000 -1.12549866e-09 0.7500010 0 0.7700000 0 \
    0.7700010 1.2643114e-09 0.7800000 1.2643114e-09 0.7800010 0 0.7900000 0 \
    0.7900010 4.35840489e-10 0.8000000 4.35840489e-10 0.8000010 -9.60632602e-10 0.8100000 -9.60632602e-10 \
    0.8100010 1.06637607e-09 0.8200000 1.06637607e-09 0.8200010 0 0.8300000 0 \
    0.8300010 -1.03805568e-09 0.8400000 -1.03805568e-09 0.8400010 1.41940385e-09 0.8500000 1.41940385e-09 \
    0.8500010 0 0.8700000 0 0.8700010 -9.96513265e-10 0.8800000 -9.96513265e-10 \
    0.8800010 1.3395473e-09 0.8900000 1.3395473e-09 0.8900010 5.62341074e-10 0.9000000 5.62341074e-10 \
    0.9000010 -9.20833707e-10 0.9100000 -9.20833707e-10 0.9100010 2.96829338e-10 0.9200000 2.96829338e-10 \
    0.9200010 1.42104661e-09 0.9300000 1.42104661e-09 0.9300010 0 0.9400000 0 \
    0.9400010 -1.24287386e-09 0.9500000 -1.24287386e-09 0.9500010 1.47529154e-09 0.9600000 1.47529154e-09 \
    0.9600010 0 0.9700000 0 0.9700010 -1.14887622e-09 0.9800000 -1.14887622e-09 \
    0.9800010 -2.16013398e-10 0.9900000 -2.16013398e-10 0.9900010 1.41582261e-09 1.0000000 1.41582261e-09 \
    1.0000010 -1.19010198e-09 1.0100000 -1.19010198e-09 1.0100010 -1.47789219e-10 1.0200000 -1.47789219e-10 \
    1.0200010 8.18574971e-10 1.0300000 8.18574971e-10 1.0300010 -1.14685312e-09 1.0400000 -1.14685312e-09 \
    1.0400010 1.01249011e-09 1.0500000 1.01249011e-09 1.0500010 -9.30103168e-10 1.0600000 -9.30103168e-10 \
    1.0600010 8.87773573e-11 1.0700000 8.87773573e-11 1.0700010 3.87481358e-10 1.0800000 3.87481358e-10 \
    1.0800010 2.90709166e-10 1.0900000 2.90709166e-10 1.0900010 8.49947487e-10 1.1000000 8.49947487e-10 \
    1.1000010 -1.08288808e-09 1.1100000 -1.08288808e-09 1.1100010 8.38587155e-10 1.1200000 8.38587155e-10 \
    1.1200010 -8.86578153e-10 1.1300000 -8.86578153e-10 1.1300010 0 1.1400000 0 \
    1.1400010 9.6396153e-10 1.1500000 9.6396153e-10 1.1500010 -1.22760164e-09 1.1600000 -1.22760164e-09 \
    1.1600010 0 1.1700000 0 1.1700010 1.31097584e-09 1.1800000 1.31097584e-09 \
    1.1800010 -9.38929853e-10 1.1900000 -9.38929853e-10 1.1900010 1.25753342e-09 1.2000000 1.25753342e-09 \
    1.2000010 -1.05058417e-09 1.2100000 -1.05058417e-09 1.2100010 1.05272359e-09 1.2200000 1.05272359e-09 \
    1.2200010 0 1.2500000 0 1.2500010 -1.17325329e-09 1.2600000 -1.17325329e-09 \
    1.2600010 1.00846214e-09 1.2700000 1.00846214e-09 1.2700010 0 1.3000000 0 \
    1.3000010 6.2111416e-10 1.3100000 6.2111416e-10 1.3100010 0 1.3500000 0 \
    1.3500010 -9.34837193e-10 1.3600000 -9.34837193e-10 1.3600010 3.28224028e-10 1.3700000 3.28224028e-10 \
    1.3700010 1.34752566e-09 1.3800000 1.34752566e-09 1.3800010 0 1.3900000 0 \
    1.3900010 4.69188457e-10 1.4000000 4.69188457e-10 1.4000010 -1.28792374e-09 1.4100000 -1.28792374e-09 \
    1.4100010 7.88081156e-10 1.4200000 7.88081156e-10 1.4200010 0 1.4300000 0 \
    1.4300010 -1.03953295e-09 1.4400000 -1.03953295e-09 1.4400010 -2.18003202e-10 1.4500000 -2.18003202e-10 \
    1.4500010 1.68019124e-11 1.4600000 1.68019124e-11 1.4600010 0 1.4700000 0 \
    1.4700010 2.56311344e-10 1.4800000 2.56311344e-10 1.4800010 2.36383444e-10 1.4900000 2.36383444e-10 \
    1.4900010 0 1.5000000 0 1.5000010 -4.38444777e-10 1.5100000 -4.38444777e-10 \
    1.5100010 1.11752902e-09 1.5200000 1.11752902e-09 1.5200010 0 1.5400000 0 \
    1.5400010 -1.17754855e-09 1.5500000 -1.17754855e-09 1.5500010 1.41954852e-09 1.5600000 1.41954852e-09 \
    1.5600010 3.13902966e-10 1.5700000 3.13902966e-10 1.5700010 -1.06050193e-09 1.5800000 -1.06050193e-09 \
    1.5800010 1.43583666e-09 1.5900000 1.43583666e-09 1.5900010 0 1.6300000 0 \
    1.6300010 -1.23920479e-09 1.6400000 -1.23920479e-09 1.6400010 7.25049123e-10 1.6500000 7.25049123e-10 \
    1.6500010 0 1.6800000 0 1.6800010 5.50673927e-10 1.6900000 5.50673927e-10 \
    1.6900010 0 1.7300000 0 1.7300010 -1.07189997e-09 1.7400000 -1.07189997e-09 \
    1.7400010 8.50840424e-10 1.7500000 8.50840424e-10 1.7500010 -1.28364454e-09 1.7600000 -1.28364454e-09 \
    1.7600010 1.43872871e-09 1.7700000 1.43872871e-09 1.7700010 0 1.7800000 0 \
    1.7800010 1.11783949e-10 1.7900000 1.11783949e-10 1.7900010 0 1.8300000 0 \
    1.8300010 2.55273896e-11 1.8400000 2.55273896e-11 1.8400010 -9.24683763e-10 1.8500000 -9.24683763e-10 \
    1.8500010 1.23639774e-09 1.8600000 1.23639774e-09 1.8600010 0 1.8700000 0 \
    1.8700010 2.95800252e-10 1.8800000 2.95800252e-10 1.8800010 0 1.9000000 0 \
    1.9000010 2.83359588e-10 1.9100000 2.83359588e-10 1.9100010 0 1.9200000 0 \
    1.9200010 5.06499311e-10 1.9300000 5.06499311e-10 1.9300010 6.17315721e-10 1.9400000 6.17315721e-10 \
    1.9400010 -1.22952872e-09 1.9500000 -1.22952872e-09 1.9500010 1.14959249e-09 1.9600000 1.14959249e-09 \
    1.9600010 0 1.9700000 0 1.9700010 -1.2975113e-09 1.9800000 -1.2975113e-09 \
    1.9800010 1.0041258e-10 1.9900000 1.0041258e-10 1.9900010 1.37205635e-09 2.0000000 1.37205635e-09 \
    2.0000010 0 2.0200000 0 2.0200010 5.97950016e-10 2.0300000 5.97950016e-10 \
    2.0300010 0 2.0400000 0 2.0400010 5.94970575e-10 2.0500000 5.94970575e-10 \
    2.0500010 3.22351588e-10 2.0600000 3.22351588e-10 2.0600010 -8.29938118e-10 2.0700000 -8.29938118e-10 \
    2.0700010 1.07829898e-09 2.0800000 1.07829898e-09 2.0800010 0 2.1100000 0 \
    2.1100010 -1.02127565e-09 2.1200000 -1.02127565e-09 2.1200010 2.96675685e-10 2.1300000 2.96675685e-10 \
    2.1300010 2.16401954e-11 2.1400000 2.16401954e-11 2.1400010 0 2.1500000 0 \
    2.1500010 3.83748925e-10 2.1600000 3.83748925e-10 2.1600010 -1.19967021e-09 2.1700000 -1.19967021e-09 \
    2.1700010 1.40160298e-09 2.1800000 1.40160298e-09 2.1800010 3.27921003e-10 2.1900000 3.27921003e-10 \
    2.1900010 -1.25644174e-09 2.2000000 -1.25644174e-09 2.2000010 1.40616371e-10 2.2100000 1.40616371e-10 \
    2.2100010 0 2.2200000 0 2.2200010 1.07291781e-09 2.2300000 1.07291781e-09 \
    2.2300010 0 2.2400000 0 2.2400010 -1.23439123e-09 2.2500000 -1.23439123e-09 \
    2.2500010 1.07480679e-09 2.2600000 1.07480679e-09 2.2600010 0 2.2800000 0 \
    2.2800010 4.97634403e-10 2.2900000 4.97634403e-10 2.2900010 -1.13118607e-09 2.3000000 -1.13118607e-09 \
    2.3000010 -2.44080569e-10 2.3100000 -2.44080569e-10 2.3100010 0 2.3200000 0 \
    2.3200010 2.97402264e-10 2.3300000 2.97402264e-10 2.3300010 0 2.3400000 0 \
    2.3400010 1.81893614e-10 2.3500000 1.81893614e-10 2.3500010 -1.54794304e-10 2.3600000 -1.54794304e-10 \
    2.3600010 2.84338988e-11 2.3700000 2.84338988e-11 2.3700010 1.21997937e-09 2.3800000 1.21997937e-09 \
    2.3800010 -6.54612826e-12 2.3900000 -6.54612826e-12 2.3900010 -3.30446203e-11 2.4000000 -3.30446203e-11 \
    2.4000010 4.05398735e-11 2.4100000 4.05398735e-11 2.4100010 0 2.4200000 0 \
    2.4200010 -9.90970544e-10 2.4300000 -9.90970544e-10 2.4300010 1.26369285e-09 2.4400000 1.26369285e-09 \
    2.4400010 0 2.4700000 0 2.4700010 -8.09359201e-10 2.4800000 -8.09359201e-10 \
    2.4800010 1.39180775e-09 2.4900000 1.39180775e-09 2.4900010 0 2.5200000 0 \
    2.5200010 -8.23444126e-10 2.5300000 -8.23444126e-10 2.5300010 1.37685859e-09 2.5400000 1.37685859e-09 \
    2.5400010 0 2.5500000 0 2.5500010 -1.24848592e-09 2.5600000 -1.24848592e-09 \
    2.5600010 0 2.5700000 0 2.5700010 -6.68492086e-10 2.5800000 -6.68492086e-10 \
    2.5800010 9.47926092e-10 2.5900000 9.47926092e-10 2.5900010 0 2.6200000 0 \
    2.6200010 -1.15339159e-09 2.6300000 -1.15339159e-09 2.6300010 0 2.6400000 0 \
    2.6400010 7.08766425e-10 2.6500000 7.08766425e-10 2.6500010 0 2.6700000 0 \
    2.6700010 -8.83883459e-10 2.6800000 -8.83883459e-10 2.6800010 1.45375875e-09 2.6900000 1.45375875e-09 \
    2.6900010 0 2.7200000 0 2.7200010 -1.11317955e-09 2.7300000 -1.11317955e-09 \
    2.7300010 0 2.7400000 0 2.7400010 -6.43084589e-10 2.7500000 -6.43084589e-10 \
    2.7500010 9.25277316e-10 2.7600000 9.25277316e-10 2.7600010 0 2.7900000 0 \
    2.7900010 -1.12915229e-09 2.8000000 -1.12915229e-09 2.8000010 -2.01403997e-10 2.8100000 -2.01403997e-10 \
    2.8100010 1.42299266e-09 2.8200000 1.42299266e-09 2.8200010 -1.70849769e-10 2.8300000 -1.70849769e-10 \
    2.8300010 0 2.8500000 0 2.8500010 3.12597129e-10 2.8600000 3.12597129e-10 \
    2.8600010 0 2.8700000 0 2.8700010 -1.07543094e-09 2.8800000 -1.07543094e-09 \
    2.8800010 2.6451152e-10 2.8900000 2.6451152e-10 2.8900010 1.18406693e-09 2.9000000 1.18406693e-09 \
    2.9000010 -1.0165169e-09 2.9100000 -1.0165169e-09 2.9100010 9.35178243e-10 2.9200000 9.35178243e-10 \
    2.9200010 0 2.9300000 0 2.9300010 -5.85426036e-10 2.9400000 -5.85426036e-10 \
    2.9400010 3.7939055e-10 2.9500000 3.7939055e-10 2.9500010 9.35700977e-10 2.9600000 9.35700977e-10 \
    2.9600010 2.72309279e-10 2.9700000 2.72309279e-10 2.9700010 -8.06490761e-10 2.9800000 -8.06490761e-10 \
    2.9800010 0 2.9900000 0 2.9900010 7.69006968e-10 3.0000000 7.69006968e-10 \
    3.0000010 0 3.0100000 0 3.0100010 -1.17472697e-09 3.0200000 -1.17472697e-09 \
    3.0200010 8.98357926e-10 3.0300000 8.98357926e-10 3.0300010 -1.02337172e-09 3.0400000 -1.02337172e-09 \
    3.0400010 1.11625178e-09 3.0500000 1.11625178e-09 3.0500010 0 3.0700000 0 \
    3.0700010 -9.74332654e-10 3.0800000 -9.74332654e-10 3.0800010 1.3711121e-09 3.0900000 1.3711121e-09 \
    3.0900010 0 3.1000000 0 3.1000010 -6.88734601e-10 3.1100000 -6.88734601e-10 \
    3.1100010 9.31915782e-10 3.1200000 9.31915782e-10 3.1200010 1.7090882e-10 3.1300000 1.7090882e-10 \
    3.1300010 -1.10902907e-09 3.1400000 -1.10902907e-09 3.1400010 9.16694898e-10 3.1500000 9.16694898e-10 \
    3.1500010 -1.21548585e-09 3.1600000 -1.21548585e-09 3.1600010 1.10307515e-09 3.1700000 1.10307515e-09 \
    3.1700010 -9.50671171e-10 3.1800000 -9.50671171e-10 3.1800010 1.16259187e-09 3.1900000 1.16259187e-09 \
    3.1900010 0 3.2000000 0 3.2000010 -1.02911133e-09 3.2100000 -1.02911133e-09 \
    3.2100010 -1.24233988e-10 3.2200000 -1.24233988e-10 3.2200010 1.44495515e-09 3.2300000 1.44495515e-09 \
    3.2300010 0 3.2400000 0 3.2400010 6.09863902e-10 3.2500000 6.09863902e-10 \
    3.2500010 9.80219507e-11 3.2600000 9.80219507e-11 3.2600010 1.62970964e-10 3.2700000 1.62970964e-10 \
    3.2700010 1.43136954e-10 3.2800000 1.43136954e-10 3.2800010 -1.0092791e-09 3.2900000 -1.0092791e-09 \
    3.2900010 1.09880702e-09 3.3000000 1.09880702e-09 3.3000010 0 3.3100000 0 \
    3.3100010 2.77747982e-11 3.3200000 2.77747982e-11 3.3200010 4.4881988e-10 3.3300000 4.4881988e-10 \
    3.3300010 -1.05108966e-09 3.3400000 -1.05108966e-09 3.3400010 2.60728536e-10 3.3500000 2.60728536e-10 \
    3.3500010 1.54965227e-10 3.3600000 1.54965227e-10 3.3600010 0 3.3700000 0 \
    3.3700010 -9.73970657e-11 3.3800000 -9.73970657e-11 3.3800010 1.0941697e-09 3.3900000 1.0941697e-09 \
    3.3900010 0 3.4100000 0 3.4100010 3.29796906e-10 3.4200000 3.29796906e-10 \
    3.4200010 2.44795e-10 3.4300000 2.44795e-10 3.4300010 0 3.4500000 0 \
    3.4500010 -1.13911251e-09 3.4600000 -1.13911251e-09 3.4600010 -4.5380176e-10 3.4700000 -4.5380176e-10 \
    3.4700010 2.52800378e-11 3.4800000 2.52800378e-11 3.4800010 9.55160356e-10 3.4900000 9.55160356e-10 \
    3.4900010 -1.23516803e-09 3.5000000 -1.23516803e-09 3.5000010 1.44677998e-09 3.5100000 1.44677998e-09 \
    3.5100010 0 3.5400000 0 3.5400010 -1.14916711e-09 3.5500000 -1.14916711e-09 \
    3.5500010 1.06389944e-09 3.5600000 1.06389944e-09 3.5600010 -1.05171783e-09 3.5700000 -1.05171783e-09 \
    3.5700010 -2.05395868e-10 3.5800000 -2.05395868e-10 3.5800010 1.20869305e-09 3.5900000 1.20869305e-09 \
    3.5900010 0 3.6200000 0 3.6200010 -1.0662042e-09 3.6300000 -1.0662042e-09 \
    3.6300010 8.54878793e-10 3.6400000 8.54878793e-10 3.6400010 0 3.6700000 0 \
    3.6700010 -1.02146275e-09 3.6800000 -1.02146275e-09 3.6800010 1.20339936e-09 3.6900000 1.20339936e-09 \
    3.6900010 0 3.7100000 0 3.7100010 -1.09604588e-09 3.7200000 -1.09604588e-09 \
    3.7200010 2.56891116e-10 3.7300000 2.56891116e-10 3.7300010 1.3118487e-09 3.7400000 1.3118487e-09 \
    3.7400010 0 3.7700000 0 3.7700010 -1.11831147e-09 3.7800000 -1.11831147e-09 \
    3.7800010 1.0586707e-09 3.7900000 1.0586707e-09 3.7900010 0 3.8200000 0 \
    3.8200010 -1.17144128e-09 3.8300000 -1.17144128e-09 3.8300010 0 3.8400000 0 \
    3.8400010 8.11629675e-10 3.8500000 8.11629675e-10 3.8500010 0 3.8700000 0 \
    3.8700010 -1.14922864e-09 3.8800000 -1.14922864e-09 3.8800010 1.15916964e-09 3.8900000 1.15916964e-09 \
    3.8900010 0 3.9200000 0 3.9200010 -3.38415693e-10 3.9300000 -3.38415693e-10 \
    3.9300010 -1.82769944e-10 3.9400000 -1.82769944e-10 3.9400010 6.32176973e-10 3.9500000 6.32176973e-10 \
    3.9500010 -4.11743545e-10 3.9600000 -4.11743545e-10 3.9600010 0 4.0000000 0 \
    4.0000010 5.07571067e-10 4.0100000 5.07571067e-10 4.0100010 0 4.0600000 0 ]
Rsh12 (n_ig12 0) resistor r=1G

X13 (n_in 0 n_ig13 n_rm13) ecfet_v3 Rinit=1642.09131525 A_stdp=0
ig13 (0 n_ig13) isource type=pwl wave=[ 0.0000000 0 0.0100000 0 0.0100010 1.6284003e-10 0.0200000 1.6284003e-10 \
    0.0200010 0 0.0300000 0 0.0300010 1.06777743e-09 0.0400000 1.06777743e-09 \
    0.0400010 5.85773689e-10 0.0500000 5.85773689e-10 0.0500010 0 0.0600000 0 \
    0.0600010 -1.07643459e-09 0.0700000 -1.07643459e-09 0.0700010 0 0.0800000 0 \
    0.0800010 -2.16625957e-10 0.0900000 -2.16625957e-10 0.0900010 1.1916873e-09 0.1000000 1.1916873e-09 \
    0.1000010 -9.46834772e-10 0.1100000 -9.46834772e-10 0.1100010 1.18609686e-09 0.1200000 1.18609686e-09 \
    0.1200010 0 0.1500000 0 0.1500010 7.08321968e-10 0.1600000 7.08321968e-10 \
    0.1600010 0 0.2000000 0 0.2000010 -1.01440877e-09 0.2100000 -1.01440877e-09 \
    0.2100010 8.38660799e-10 0.2200000 8.38660799e-10 0.2200010 0 0.2400000 0 \
    0.2400010 -7.30522633e-10 0.2500000 -7.30522633e-10 0.2500010 0 0.2600000 0 \
    0.2600010 -2.01514047e-10 0.2700000 -2.01514047e-10 0.2700010 -1.37177681e-10 0.2800000 -1.37177681e-10 \
    0.2800010 1.06504062e-09 0.2900000 1.06504062e-09 0.2900010 -1.2004055e-09 0.3000000 -1.2004055e-09 \
    0.3000010 1.91442308e-10 0.3100000 1.91442308e-10 0.3100010 -2.3011464e-10 0.3200000 -2.3011464e-10 \
    0.3200010 0 0.3300000 0 0.3300010 6.26248481e-10 0.3400000 6.26248481e-10 \
    0.3400010 0 0.3500000 0 0.3500010 -9.50766387e-10 0.3600000 -9.50766387e-10 \
    0.3600010 1.11900328e-09 0.3700000 1.11900328e-09 0.3700010 -1.06590974e-09 0.3800000 -1.06590974e-09 \
    0.3800010 1.0054267e-10 0.3900000 1.0054267e-10 0.3900010 0 0.4000000 0 \
    0.4000010 5.51557416e-10 0.4100000 5.51557416e-10 0.4100010 -9.5238572e-10 0.4200000 -9.5238572e-10 \
    0.4200010 -3.27379372e-10 0.4300000 -3.27379372e-10 0.4300010 0 0.4400000 0 \
    0.4400010 -1.93534076e-10 0.4500000 -1.93534076e-10 0.4500010 1.18554227e-09 0.4600000 1.18554227e-09 \
    0.4600010 0 0.4800000 0 0.4800010 -9.74086184e-10 0.4900000 -9.74086184e-10 \
    0.4900010 8.62296539e-10 0.5000000 8.62296539e-10 0.5000010 -5.13741925e-11 0.5100000 -5.13741925e-11 \
    0.5100010 0 0.5400000 0 0.5400010 -9.70729903e-10 0.5500000 -9.70729903e-10 \
    0.5500010 1.34830538e-09 0.5600000 1.34830538e-09 0.5600010 0 0.6000000 0 \
    0.6000010 -1.25049274e-09 0.6100000 -1.25049274e-09 0.6100010 8.70825335e-10 0.6200000 8.70825335e-10 \
    0.6200010 0 0.6300000 0 0.6300010 -9.26232443e-10 0.6400000 -9.26232443e-10 \
    0.6400010 8.17201987e-10 0.6500000 8.17201987e-10 0.6500010 -1.11491747e-09 0.6600000 -1.11491747e-09 \
    0.6600010 0 0.6700000 0 0.6700010 3.8720791e-10 0.6800000 3.8720791e-10 \
    0.6800010 0 0.7000000 0 0.7000010 -1.03997843e-09 0.7100000 -1.03997843e-09 \
    0.7100010 -8.51612751e-12 0.7200000 -8.51612751e-12 0.7200010 0 0.7400000 0 \
    0.7400010 1.15251842e-09 0.7500000 1.15251842e-09 0.7500010 0 0.7800000 0 \
    0.7800010 -1.07872114e-09 0.7900000 -1.07872114e-09 0.7900010 8.65460577e-10 0.8000000 8.65460577e-10 \
    0.8000010 -8.91916948e-10 0.8100000 -8.91916948e-10 0.8100010 1.23756513e-09 0.8200000 1.23756513e-09 \
    0.8200010 -7.96197893e-10 0.8300000 -7.96197893e-10 0.8300010 0 0.8400000 0 \
    0.8400010 1.29819289e-09 0.8500000 1.29819289e-09 0.8500010 -1.06985745e-09 0.8600000 -1.06985745e-09 \
    0.8600010 0 0.8700000 0 0.8700010 1.42842819e-09 0.8800000 1.42842819e-09 \
    0.8800010 -6.49239862e-10 0.8900000 -6.49239862e-10 0.8900010 1.48895344e-09 0.9000000 1.48895344e-09 \
    0.9000010 -1.1246394e-09 0.9100000 -1.1246394e-09 0.9100010 8.69887748e-11 0.9200000 8.69887748e-11 \
    0.9200010 2.7799327e-10 0.9300000 2.7799327e-10 0.9300010 1.45883288e-09 0.9400000 1.45883288e-09 \
    0.9400010 -1.27385965e-09 0.9500000 -1.27385965e-09 0.9500010 9.62931504e-10 0.9600000 9.62931504e-10 \
    0.9600010 0 0.9700000 0 0.9700010 -1.17615347e-09 0.9800000 -1.17615347e-09 \
    0.9800010 8.85568136e-10 0.9900000 8.85568136e-10 0.9900010 -9.28439842e-10 1.0000000 -9.28439842e-10 \
    1.0000010 -2.94553205e-10 1.0100000 -2.94553205e-10 1.0100010 -1.7295906e-10 1.0200000 -1.7295906e-10 \
    1.0200010 1.25033439e-09 1.0300000 1.25033439e-09 1.0300010 2.50711135e-10 1.0400000 2.50711135e-10 \
    1.0400010 1.4413683e-10 1.0500000 1.4413683e-10 1.0500010 0 1.0700000 0 \
    1.0700010 -1.19942857e-09 1.0800000 -1.19942857e-09 1.0800010 -5.80866399e-10 1.0900000 -5.80866399e-10 \
    1.0900010 1.34577446e-09 1.1000000 1.34577446e-09 1.1000010 0 1.1100000 0 \
    1.1100010 -1.19599794e-09 1.1200000 -1.19599794e-09 1.1200010 8.87475494e-10 1.1300000 8.87475494e-10 \
    1.1300010 0 1.1500000 0 1.1500010 4.30123842e-10 1.1600000 4.30123842e-10 \
    1.1600010 -1.01095656e-09 1.1700000 -1.01095656e-09 1.1700010 7.10540196e-10 1.1800000 7.10540196e-10 \
    1.1800010 0 1.2100000 0 1.2100010 -1.2919284e-09 1.2200000 -1.2919284e-09 \
    1.2200010 0 1.2300000 0 1.2300010 4.66620511e-10 1.2400000 4.66620511e-10 \
    1.2400010 0 1.2600000 0 1.2600010 3.93300397e-10 1.2700000 3.93300397e-10 \
    1.2700010 0 1.3100000 0 1.3100010 -1.0945505e-09 1.3200000 -1.0945505e-09 \
    1.3200010 9.0941176e-10 1.3300000 9.0941176e-10 1.3300010 0 1.3600000 0 \
    1.3600010 -1.13993747e-09 1.3700000 -1.13993747e-09 1.3700010 9.14017765e-10 1.3800000 9.14017765e-10 \
    1.3800010 0 1.4100000 0 1.4100010 1.48969284e-10 1.4200000 1.48969284e-10 \
    1.4200010 -1.05489488e-09 1.4300000 -1.05489488e-09 1.4300010 1.14679701e-09 1.4400000 1.14679701e-09 \
    1.4400010 0 1.4500000 0 1.4500010 3.143454e-10 1.4600000 3.143454e-10 \
    1.4600010 -9.83574626e-10 1.4700000 -9.83574626e-10 1.4700010 -1.63801852e-10 1.4800000 -1.63801852e-10 \
    1.4800010 2.41010808e-10 1.4900000 2.41010808e-10 1.4900010 0 1.5000000 0 \
    1.5000010 1.41354488e-09 1.5100000 1.41354488e-09 1.5100010 -6.12593332e-10 1.5200000 -6.12593332e-10 \
    1.5200010 9.39070199e-10 1.5300000 9.39070199e-10 1.5300010 -1.09350875e-09 1.5400000 -1.09350875e-09 \
    1.5400010 2.37270189e-10 1.5500000 2.37270189e-10 1.5500010 1.37187178e-09 1.5600000 1.37187178e-09 \
    1.5600010 2.69280129e-11 1.5700000 2.69280129e-11 1.5700010 0 1.6000000 0 \
    1.6000010 7.76288243e-11 1.6100000 7.76288243e-11 1.6100010 0 1.6200000 0 \
    1.6200010 -9.82488612e-10 1.6300000 -9.82488612e-10 1.6300010 -1.70314585e-10 1.6400000 -1.70314585e-10 \
    1.6400010 1.28898354e-09 1.6500000 1.28898354e-09 1.6500010 0 1.6800000 0 \
    1.6800010 -1.14586783e-09 1.6900000 -1.14586783e-09 1.6900010 0 1.7000000 0 \
    1.7000010 -2.11987755e-10 1.7100000 -2.11987755e-10 1.7100010 0 1.7200000 0 \
    1.7200010 1.35268136e-09 1.7300000 1.35268136e-09 1.7300010 0 1.7500000 0 \
    1.7500010 1.15922839e-10 1.7600000 1.15922839e-10 1.7600010 -1.03171903e-09 1.7700000 -1.03171903e-09 \
    1.7700010 -1.19217256e-11 1.7800000 -1.19217256e-11 1.7800010 1.43505143e-09 1.7900000 1.43505143e-09 \
    1.7900010 0 1.8200000 0 1.8200010 2.87459437e-10 1.8300000 2.87459437e-10 \
    1.8300010 1.0959597e-10 1.8400000 1.0959597e-10 1.8400010 0 1.8500000 0 \
    1.8500010 -1.28095294e-09 1.8600000 -1.28095294e-09 1.8600010 2.4792247e-10 1.8700000 2.4792247e-10 \
    1.8700010 9.43211566e-10 1.8800000 9.43211566e-10 1.8800010 -1.05908524e-09 1.8900000 -1.05908524e-09 \
    1.8900010 -2.46782051e-10 1.9000000 -2.46782051e-10 1.9000010 -2.40051384e-10 1.9100000 -2.40051384e-10 \
    1.9100010 0 1.9200000 0 1.9200010 1.27117728e-09 1.9300000 1.27117728e-09 \
    1.9300010 0 1.9500000 0 1.9500010 -1.09733785e-09 1.9600000 -1.09733785e-09 \
    1.9600010 0 1.9700000 0 1.9700010 7.12103941e-10 1.9800000 7.12103941e-10 \
    1.9800010 0 2.0000000 0 2.0000010 -1.23527812e-09 2.0100000 -1.23527812e-09 \
    2.0100010 0 2.0200000 0 2.0200010 1.06459929e-09 2.0300000 1.06459929e-09 \
    2.0300010 0 2.0500000 0 2.0500010 -1.24936043e-09 2.0600000 -1.24936043e-09 \
    2.0600010 9.72034072e-10 2.0700000 9.72034072e-10 2.0700010 -1.23311212e-09 2.0800000 -1.23311212e-09 \
    2.0800010 0 2.0900000 0 2.0900010 5.5961744e-10 2.1000000 5.5961744e-10 \
    2.1000010 -9.79335012e-10 2.1100000 -9.79335012e-10 2.1100010 1.25604604e-09 2.1200000 1.25604604e-09 \
    2.1200010 0 2.1500000 0 2.1500010 8.47364194e-10 2.1600000 8.47364194e-10 \
    2.1600010 0 2.1700000 0 2.1700010 -1.11204221e-09 2.1800000 -1.11204221e-09 \
    2.1800010 8.9558303e-10 2.1900000 8.9558303e-10 2.1900010 0 2.2200000 0 \
    2.2200010 -1.17888319e-09 2.2300000 -1.17888319e-09 2.2300010 0 2.2400000 0 \
    2.2400010 5.15875226e-10 2.2500000 5.15875226e-10 2.2500010 0 2.2600000 0 \
    2.2600010 -1.02236974e-09 2.2700000 -1.02236974e-09 2.2700010 1.19475995e-10 2.2800000 1.19475995e-10 \
    2.2800010 9.05737565e-10 2.2900000 9.05737565e-10 2.2900010 0 2.3200000 0 \
    2.3200010 -1.10985936e-09 2.3300000 -1.10985936e-09 2.3300010 0 2.3400000 0 \
    2.3400010 7.00235234e-10 2.3500000 7.00235234e-10 2.3500010 0 2.3700000 0 \
    2.3700010 -1.24622625e-09 2.3800000 -1.24622625e-09 2.3800010 7.79177503e-10 2.3900000 7.79177503e-10 \
    2.3900010 0 2.4200000 0 2.4200010 -1.01574806e-09 2.4300000 -1.01574806e-09 \
    2.4300010 -6.53598089e-11 2.4400000 -6.53598089e-11 2.4400010 7.17812459e-10 2.4500000 7.17812459e-10 \
    2.4500010 0 2.4700000 0 2.4700010 -9.8267991e-10 2.4800000 -9.8267991e-10 \
    2.4800010 1.27898382e-09 2.4900000 1.27898382e-09 2.4900010 0 2.5200000 0 \
    2.5200010 -1.03175399e-09 2.5300000 -1.03175399e-09 2.5300010 1.32317807e-09 2.5400000 1.32317807e-09 \
    2.5400010 0 2.5700000 0 2.5700010 -1.21449945e-09 2.5800000 -1.21449945e-09 \
    2.5800010 1.04998072e-09 2.5900000 1.04998072e-09 2.5900010 0 2.6200000 0 \
    2.6200010 -1.17947702e-09 2.6300000 -1.17947702e-09 2.6300010 0 2.6400000 0 \
    2.6400010 -4.25642138e-10 2.6500000 -4.25642138e-10 2.6500010 1.24091636e-09 2.6600000 1.24091636e-09 \
    2.6600010 0 2.6700000 0 2.6700010 -1.03940897e-09 2.6800000 -1.03940897e-09 \
    2.6800010 1.29421593e-09 2.6900000 1.29421593e-09 2.6900010 0 2.7200000 0 \
    2.7200010 6.97035951e-10 2.7300000 6.97035951e-10 2.7300010 0 2.7700000 0 \
    2.7700010 -1.11518576e-09 2.7800000 -1.11518576e-09 2.7800010 7.53814106e-10 2.7900000 7.53814106e-10 \
    2.7900010 0 2.8000000 0 2.8000010 -1.09049256e-09 2.8100000 -1.09049256e-09 \
    2.8100010 -1.97574831e-10 2.8200000 -1.97574831e-10 2.8200010 -5.76768738e-10 2.8300000 -5.76768738e-10 \
    2.8300010 0 2.8400000 0 2.8400010 7.48530911e-10 2.8500000 7.48530911e-10 \
    2.8500010 0 2.8600000 0 2.8600010 -1.22859757e-09 2.8700000 -1.22859757e-09 \
    2.8700010 0 2.8800000 0 2.8800010 1.14619441e-09 2.8900000 1.14619441e-09 \
    2.8900010 -1.19231753e-09 2.9000000 -1.19231753e-09 2.9000010 0 2.9100000 0 \
    2.9100010 7.54593823e-11 2.9200000 7.54593823e-11 2.9200010 0 2.9400000 0 \
    2.9400010 -6.13436182e-10 2.9500000 -6.13436182e-10 2.9500010 -1.13892398e-10 2.9600000 -1.13892398e-10 \
    2.9600010 1.34754853e-09 2.9700000 1.34754853e-09 2.9700010 0 3.0100000 0 \
    3.0100010 2.73350049e-10 3.0200000 2.73350049e-10 3.0200010 0 3.0600000 0 \
    3.0600010 1.29632809e-11 3.0700000 1.29632809e-11 3.0700010 0 3.1100000 0 \
    3.1100010 3.28192749e-10 3.1200000 3.28192749e-10 3.1200010 0 3.1400000 0 \
    3.1400010 4.68647573e-10 3.1500000 4.68647573e-10 3.1500010 0 3.1600000 0 \
    3.1600010 6.39576182e-11 3.1700000 6.39576182e-11 3.1700010 0 3.2100000 0 \
    3.2100010 6.08614793e-10 3.2200000 6.08614793e-10 3.2200010 0 3.2600000 0 \
    3.2600010 9.12511592e-11 3.2700000 9.12511592e-11 3.2700010 0 3.3100000 0 \
    3.3100010 3.70024149e-11 3.3200000 3.70024149e-11 3.3200010 0 3.3600000 0 \
    3.3600010 -1.02955466e-09 3.3700000 -1.02955466e-09 3.3700010 8.53799499e-10 3.3800000 8.53799499e-10 \
    3.3800010 0 3.4100000 0 3.4100010 5.286311e-10 3.4200000 5.286311e-10 \
    3.4200010 0 3.4600000 0 3.4600010 6.21511597e-10 3.4700000 6.21511597e-10 \
    3.4700010 0 3.5100000 0 3.5100010 2.8086909e-10 3.5200000 2.8086909e-10 \
    3.5200010 0 3.5300000 0 3.5300010 -1.21080343e-09 3.5400000 -1.21080343e-09 \
    3.5400010 1.48798127e-09 3.5500000 1.48798127e-09 3.5500010 0 3.5600000 0 \
    3.5600010 -8.79874633e-10 3.5700000 -8.79874633e-10 3.5700010 1.20254725e-10 3.5800000 1.20254725e-10 \
    3.5800010 7.8982299e-10 3.5900000 7.8982299e-10 3.5900010 3.26794133e-10 3.6000000 3.26794133e-10 \
    3.6000010 -1.17522377e-09 3.6100000 -1.17522377e-09 3.6100010 0 3.6200000 0 \
    3.6200010 6.74523237e-10 3.6300000 6.74523237e-10 3.6300010 4.3667945e-10 3.6400000 4.3667945e-10 \
    3.6400010 0 3.6500000 0 3.6500010 -1.17761001e-09 3.6600000 -1.17761001e-09 \
    3.6600010 0 3.6700000 0 3.6700010 7.32162057e-10 3.6800000 7.32162057e-10 \
    3.6800010 0 3.6900000 0 3.6900010 5.71140882e-11 3.7000000 5.71140882e-11 \
    3.7000010 -1.05904934e-09 3.7100000 -1.05904934e-09 3.7100010 8.06769193e-10 3.7200000 8.06769193e-10 \
    3.7200010 -1.22121598e-09 3.7300000 -1.22121598e-09 3.7300010 1.43298535e-09 3.7400000 1.43298535e-09 \
    3.7400010 0 3.7700000 0 3.7700010 7.0424927e-10 3.7800000 7.0424927e-10 \
    3.7800010 0 3.8200000 0 3.8200010 4.25219009e-10 3.8300000 4.25219009e-10 \
    3.8300010 0 3.8500000 0 3.8500010 5.88959621e-10 3.8600000 5.88959621e-10 \
    3.8600010 0 3.8800000 0 3.8800010 -6.49383122e-10 3.8900000 -6.49383122e-10 \
    3.8900010 9.31005081e-10 3.9000000 9.31005081e-10 3.9000010 -1.18965009e-09 3.9100000 -1.18965009e-09 \
    3.9100010 0 3.9200000 0 3.9200010 1.00916193e-09 3.9300000 1.00916193e-09 \
    3.9300010 -1.24437063e-09 3.9400000 -1.24437063e-09 3.9400010 9.25684194e-10 3.9500000 9.25684194e-10 \
    3.9500010 3.62544883e-10 3.9600000 3.62544883e-10 3.9600010 -1.20324886e-09 3.9700000 -1.20324886e-09 \
    3.9700010 3.43611541e-10 3.9800000 3.43611541e-10 3.9800010 1.10252075e-09 3.9900000 1.10252075e-09 \
    3.9900010 3.50890467e-10 4.0000000 3.50890467e-10 4.0000010 0 4.0600000 0 ]
Rsh13 (n_ig13 0) resistor r=1G

X14 (n_in 0 n_ig14 n_rm14) ecfet_v3 Rinit=1642.09131525 A_stdp=0
ig14 (0 n_ig14) isource type=pwl wave=[ 0.0000000 0 0.0300000 0 0.0300010 -1.17962357e-09 0.0400000 -1.17962357e-09 \
    0.0400010 1.04148855e-09 0.0500000 1.04148855e-09 0.0500010 -1.18758875e-09 0.0600000 -1.18758875e-09 \
    0.0600010 1.00129987e-09 0.0700000 1.00129987e-09 0.0700010 -8.82363369e-10 0.0800000 -8.82363369e-10 \
    0.0800010 -8.58273218e-12 0.0900000 -8.58273218e-12 0.0900010 2.24699387e-10 0.1000000 2.24699387e-10 \
    0.1000010 0 0.1100000 0 0.1100010 -3.9964844e-10 0.1200000 -3.9964844e-10 \
    0.1200010 9.91568105e-10 0.1300000 9.91568105e-10 0.1300010 0 0.1600000 0 \
    0.1600010 -1.02515278e-09 0.1700000 -1.02515278e-09 0.1700010 0 0.1800000 0 \
    0.1800010 1.09946447e-09 0.1900000 1.09946447e-09 0.1900010 3.04517875e-10 0.2000000 3.04517875e-10 \
    0.2000010 0 0.2100000 0 0.2100010 -1.22969818e-09 0.2200000 -1.22969818e-09 \
    0.2200010 0 0.2300000 0 0.2300010 4.15471793e-10 0.2400000 4.15471793e-10 \
    0.2400010 -1.84369861e-10 0.2500000 -1.84369861e-10 0.2500010 0 0.2600000 0 \
    0.2600010 -4.89892035e-10 0.2700000 -4.89892035e-10 0.2700010 7.03473076e-10 0.2800000 7.03473076e-10 \
    0.2800010 2.29728982e-10 0.2900000 2.29728982e-10 0.2900010 0 0.3000000 0 \
    0.3000010 -1.16469784e-09 0.3100000 -1.16469784e-09 0.3100010 1.24073766e-09 0.3200000 1.24073766e-09 \
    0.3200010 -8.6973629e-10 0.3300000 -8.6973629e-10 0.3300010 1.37994514e-09 0.3400000 1.37994514e-09 \
    0.3400010 -1.01181746e-09 0.3500000 -1.01181746e-09 0.3500010 0 0.3600000 0 \
    0.3600010 1.06030475e-10 0.3700000 1.06030475e-10 0.3700010 0 0.3800000 0 \
    0.3800010 -6.27019828e-11 0.3900000 -6.27019828e-11 0.3900010 0 0.4000000 0 \
    0.4000010 6.17362998e-10 0.4100000 6.17362998e-10 0.4100010 0 0.4300000 0 \
    0.4300010 -7.9386432e-10 0.4400000 -7.9386432e-10 0.4400010 1.19590453e-09 0.4500000 1.19590453e-09 \
    0.4500010 0 0.4700000 0 0.4700010 3.10384155e-10 0.4800000 3.10384155e-10 \
    0.4800010 -1.00640328e-09 0.4900000 -1.00640328e-09 0.4900010 8.07649538e-10 0.5000000 8.07649538e-10 \
    0.5000010 0 0.5300000 0 0.5300010 6.38972053e-10 0.5400000 6.38972053e-10 \
    0.5400010 0 0.5800000 0 0.5800010 -1.1070328e-09 0.5900000 -1.1070328e-09 \
    0.5900010 0 0.6000000 0 0.6000010 6.39888196e-10 0.6100000 6.39888196e-10 \
    0.6100010 0 0.6300000 0 0.6300010 -1.01855416e-09 0.6400000 -1.01855416e-09 \
    0.6400010 6.75391384e-10 0.6500000 6.75391384e-10 0.6500010 0 0.6700000 0 \
    0.6700010 5.91586361e-10 0.6800000 5.91586361e-10 0.6800010 -9.85004295e-10 0.6900000 -9.85004295e-10 \
    0.6900010 9.21982421e-10 0.7000000 9.21982421e-10 0.7000010 0 0.7300000 0 \
    0.7300010 -7.13032229e-10 0.7400000 -7.13032229e-10 0.7400010 1.19725113e-09 0.7500000 1.19725113e-09 \
    0.7500010 0 0.7800000 0 0.7800010 -1.06666037e-09 0.7900000 -1.06666037e-09 \
    0.7900010 9.49588277e-10 0.8000000 9.49588277e-10 0.8000010 0 0.8300000 0 \
    0.8300010 -9.86028835e-10 0.8400000 -9.86028835e-10 0.8400010 8.8251352e-10 0.8500000 8.8251352e-10 \
    0.8500010 0 0.8600000 0 0.8600010 -8.01823065e-10 0.8700000 -8.01823065e-10 \
    0.8700010 -2.2102454e-10 0.8800000 -2.2102454e-10 0.8800010 1.31839215e-09 0.8900000 1.31839215e-09 \
    0.8900010 0 0.9000000 0 0.9000010 -1.18777607e-09 0.9100000 -1.18777607e-09 \
    0.9100010 -2.38414895e-10 0.9200000 -2.38414895e-10 0.9200010 1.36061171e-09 0.9300000 1.36061171e-09 \
    0.9300010 2.31471399e-10 0.9400000 2.31471399e-10 0.9400010 -8.44446855e-10 0.9500000 -8.44446855e-10 \
    0.9500010 9.37442142e-10 0.9600000 9.37442142e-10 0.9600010 -1.04513346e-09 0.9700000 -1.04513346e-09 \
    0.9700010 -1.25339184e-11 0.9800000 -1.25339184e-11 0.9800010 1.09811995e-09 0.9900000 1.09811995e-09 \
    0.9900010 5.05622628e-10 1.0000000 5.05622628e-10 1.0000010 -1.28441131e-09 1.0100000 -1.28441131e-09 \
    1.0100010 8.01900023e-10 1.0200000 8.01900023e-10 1.0200010 3.28310325e-10 1.0300000 3.28310325e-10 \
    1.0300010 -8.32931073e-10 1.0400000 -8.32931073e-10 1.0400010 1.30184586e-09 1.0500000 1.30184586e-09 \
    1.0500010 -1.00465681e-09 1.0600000 -1.00465681e-09 1.0600010 1.36751466e-09 1.0700000 1.36751466e-09 \
    1.0700010 -1.28548976e-09 1.0800000 -1.28548976e-09 1.0800010 5.83955143e-10 1.0900000 5.83955143e-10 \
    1.0900010 4.48983126e-10 1.1000000 4.48983126e-10 1.1000010 0 1.1100000 0 \
    1.1100010 5.6084347e-10 1.1200000 5.6084347e-10 1.1200010 -5.93997684e-11 1.1300000 -5.93997684e-11 \
    1.1300010 0 1.1500000 0 1.1500010 -8.38421494e-10 1.1600000 -8.38421494e-10 \
    1.1600010 0 1.1700000 0 1.1700010 4.3987263e-10 1.1800000 4.3987263e-10 \
    1.1800010 -1.15860074e-09 1.1900000 -1.15860074e-09 1.1900010 1.41654206e-09 1.2000000 1.41654206e-09 \
    1.2000010 4.32907153e-10 1.2100000 4.32907153e-10 1.2100010 4.6687142e-10 1.2200000 4.6687142e-10 \
    1.2200010 0 1.2300000 0 1.2300010 -5.1459832e-10 1.2400000 -5.1459832e-10 \
    1.2400010 0 1.2500000 0 1.2500010 1.38467134e-09 1.2600000 1.38467134e-09 \
    1.2600010 4.31955255e-10 1.2700000 4.31955255e-10 1.2700010 0 1.2800000 0 \
    1.2800010 -9.07205951e-10 1.2900000 -9.07205951e-10 1.2900010 -4.79937399e-11 1.3000000 -4.79937399e-11 \
    1.3000010 8.78407354e-10 1.3100000 8.78407354e-10 1.3100010 -1.03583156e-09 1.3200000 -1.03583156e-09 \
    1.3200010 6.14939024e-11 1.3300000 6.14939024e-11 1.3300010 0 1.3400000 0 \
    1.3400010 1.4177114e-09 1.3500000 1.4177114e-09 1.3500010 -1.04355429e-09 1.3600000 -1.04355429e-09 \
    1.3600010 1.11239473e-09 1.3700000 1.11239473e-09 1.3700010 0 1.3800000 0 \
    1.3800010 -1.12413691e-09 1.3900000 -1.12413691e-09 1.3900010 2.78400466e-10 1.4000000 2.78400466e-10 \
    1.4000010 -1.34083734e-10 1.4100000 -1.34083734e-10 1.4100010 1.0520653e-09 1.4200000 1.0520653e-09 \
    1.4200010 0 1.4400000 0 1.4400010 5.40514198e-10 1.4500000 5.40514198e-10 \
    1.4500010 0 1.4600000 0 1.4600010 -1.01548577e-09 1.4700000 -1.01548577e-09 \
    1.4700010 -4.32164926e-10 1.4800000 -4.32164926e-10 1.4800010 1.02919978e-09 1.4900000 1.02919978e-09 \
    1.4900010 -9.74126973e-10 1.5000000 -9.74126973e-10 1.5000010 8.41937434e-10 1.5100000 8.41937434e-10 \
    1.5100010 0 1.5400000 0 1.5400010 7.12667062e-10 1.5500000 7.12667062e-10 \
    1.5500010 0 1.5900000 0 1.5900010 3.47598162e-10 1.6000000 3.47598162e-10 \
    1.6000010 -6.26444641e-10 1.6100000 -6.26444641e-10 1.6100010 1.17368886e-09 1.6200000 1.17368886e-09 \
    1.6200010 0 1.6400000 0 1.6400010 5.88160361e-10 1.6500000 5.88160361e-10 \
    1.6500010 -1.08764264e-09 1.6600000 -1.08764264e-09 1.6600010 7.51251084e-10 1.6700000 7.51251084e-10 \
    1.6700010 0 1.7000000 0 1.7000010 3.88992091e-10 1.7100000 3.88992091e-10 \
    1.7100010 0 1.7500000 0 1.7500010 -2.2224386e-11 1.7600000 -2.2224386e-11 \
    1.7600010 0 1.8000000 0 1.8000010 6.02415197e-10 1.8100000 6.02415197e-10 \
    1.8100010 0 1.8300000 0 1.8300010 1.72118694e-10 1.8400000 1.72118694e-10 \
    1.8400010 0 1.8500000 0 1.8500010 6.35952434e-10 1.8600000 6.35952434e-10 \
    1.8600010 0 1.9000000 0 1.9000010 4.06505913e-10 1.9100000 4.06505913e-10 \
    1.9100010 -1.05139978e-09 1.9200000 -1.05139978e-09 1.9200010 -5.51573062e-10 1.9300000 -5.51573062e-10 \
    1.9300010 1.22057905e-09 1.9400000 1.22057905e-09 1.9400010 -1.14082267e-09 1.9500000 -1.14082267e-09 \
    1.9500010 1.27895475e-09 1.9600000 1.27895475e-09 1.9600010 0 1.9900000 0 \
    1.9900010 -1.18721595e-09 2.0000000 -1.18721595e-09 2.0000010 1.40612556e-09 2.0100000 1.40612556e-09 \
    2.0100010 -9.16871649e-10 2.0200000 -9.16871649e-10 2.0200010 1.05823473e-09 2.0300000 1.05823473e-09 \
    2.0300010 0 2.0500000 0 2.0500010 2.82215428e-10 2.0600000 2.82215428e-10 \
    2.0600010 0 2.0700000 0 2.0700010 -9.14367803e-10 2.0800000 -9.14367803e-10 \
    2.0800010 0 2.0900000 0 2.0900010 4.92443197e-10 2.1000000 4.92443197e-10 \
    2.1000010 0 2.1100000 0 2.1100010 -1.01715704e-09 2.1200000 -1.01715704e-09 \
    2.1200010 1.32698508e-09 2.1300000 1.32698508e-09 2.1300010 0 2.1400000 0 \
    2.1400010 -1.07874588e-09 2.1500000 -1.07874588e-09 2.1500010 7.54659617e-10 2.1600000 7.54659617e-10 \
    2.1600010 0 2.1900000 0 2.1900010 4.84869189e-10 2.2000000 4.84869189e-10 \
    2.2000010 0 2.2300000 0 2.2300010 -8.97447969e-10 2.2400000 -8.97447969e-10 \
    2.2400010 -3.59230218e-10 2.2500000 -3.59230218e-10 2.2500010 7.62087115e-10 2.2600000 7.62087115e-10 \
    2.2600010 0 2.2900000 0 2.2900010 -9.47807823e-10 2.3000000 -9.47807823e-10 \
    2.3000010 9.90085581e-10 2.3100000 9.90085581e-10 2.3100010 0 2.3400000 0 \
    2.3400010 -1.05615187e-09 2.3500000 -1.05615187e-09 2.3500010 1.2305296e-09 2.3600000 1.2305296e-09 \
    2.3600010 0 2.3900000 0 2.3900010 3.59260337e-10 2.4000000 3.59260337e-10 \
    2.4000010 0 2.4400000 0 2.4400010 -1.2119629e-09 2.4500000 -1.2119629e-09 \
    2.4500010 9.5052968e-10 2.4600000 9.5052968e-10 2.4600010 0 2.4900000 0 \
    2.4900010 -1.26083899e-09 2.5000000 -1.26083899e-09 2.5000010 1.07184105e-09 2.5100000 1.07184105e-09 \
    2.5100010 0 2.5400000 0 2.5400010 -1.2502263e-09 2.5500000 -1.2502263e-09 \
    2.5500010 1.13833736e-09 2.5600000 1.13833736e-09 2.5600010 0 2.5900000 0 \
    2.5900010 4.53257309e-10 2.6000000 4.53257309e-10 2.6000010 0 2.6300000 0 \
    2.6300010 -8.91893596e-10 2.6400000 -8.91893596e-10 2.6400010 1.07440966e-10 2.6500000 1.07440966e-10 \
    2.6500010 1.27758134e-09 2.6600000 1.27758134e-09 2.6600010 0 2.6900000 0 \
    2.6900010 -7.95850835e-10 2.7000000 -7.95850835e-10 2.7000010 1.08828583e-09 2.7100000 1.08828583e-09 \
    2.7100010 0 2.7400000 0 2.7400010 -1.17441917e-09 2.7500000 -1.17441917e-09 \
    2.7500010 1.09391995e-09 2.7600000 1.09391995e-09 2.7600010 0 2.7900000 0 \
    2.7900010 -1.02023622e-09 2.8000000 -1.02023622e-09 2.8000010 1.1709303e-09 2.8100000 1.1709303e-09 \
    2.8100010 0 2.8400000 0 2.8400010 -5.09280623e-10 2.8500000 -5.09280623e-10 \
    2.8500010 1.04463854e-09 2.8600000 1.04463854e-09 2.8600010 -8.71052081e-11 2.8700000 -8.71052081e-11 \
    2.8700010 0 2.8900000 0 2.8900010 -1.27571109e-09 2.9000000 -1.27571109e-09 \
    2.9000010 0 2.9100000 0 2.9100010 5.92968753e-10 2.9200000 5.92968753e-10 \
    2.9200010 0 2.9400000 0 2.9400010 -1.0568086e-09 2.9500000 -1.0568086e-09 \
    2.9500010 1.03414877e-09 2.9600000 1.03414877e-09 2.9600010 0 2.9700000 0 \
    2.9700010 1.53985946e-11 2.9800000 1.53985946e-11 2.9800010 0 2.9900000 0 \
    2.9900010 -1.06969988e-09 3.0000000 -1.06969988e-09 3.0000010 1.0840305e-09 3.0100000 1.0840305e-09 \
    3.0100010 3.90559593e-10 3.0200000 3.90559593e-10 3.0200010 0 3.0300000 0 \
    3.0300010 -9.22642283e-10 3.0400000 -9.22642283e-10 3.0400010 1.37413733e-09 3.0500000 1.37413733e-09 \
    3.0500010 2.74956583e-10 3.0600000 2.74956583e-10 3.0600010 0 3.0700000 0 \
    3.0700010 -1.13554308e-09 3.0800000 -1.13554308e-09 3.0800010 1.14254785e-09 3.0900000 1.14254785e-09 \
    3.0900010 0 3.1000000 0 3.1000010 -1.1618104e-09 3.1100000 -1.1618104e-09 \
    3.1100010 1.76685405e-10 3.1200000 1.76685405e-10 3.1200010 8.05408024e-10 3.1300000 8.05408024e-10 \
    3.1300010 0 3.1600000 0 3.1600010 -1.2941155e-09 3.1700000 -1.2941155e-09 \
    3.1700010 0 3.1800000 0 3.1800010 6.26245433e-10 3.1900000 6.26245433e-10 \
    3.1900010 0 3.2100000 0 3.2100010 -1.10828519e-09 3.2200000 -1.10828519e-09 \
    3.2200010 1.31977411e-09 3.2300000 1.31977411e-09 3.2300010 0 3.2600000 0 \
    3.2600010 2.05063344e-10 3.2700000 2.05063344e-10 3.2700010 0 3.3100000 0 \
    3.3100010 -1.18291928e-09 3.3200000 -1.18291928e-09 3.3200010 -9.42347391e-11 3.3300000 -9.42347391e-11 \
    3.3300010 1.29565598e-09 3.3400000 1.29565598e-09 3.3400010 0 3.3600000 0 \
    3.3600010 -8.55501127e-10 3.3700000 -8.55501127e-10 3.3700010 1.23791914e-09 3.3800000 1.23791914e-09 \
    3.3800010 0 3.4100000 0 3.4100010 -1.13743773e-09 3.4200000 -1.13743773e-09 \
    3.4200010 9.52722275e-10 3.4300000 9.52722275e-10 3.4300010 0 3.4600000 0 \
    3.4600010 -1.14928197e-09 3.4700000 -1.14928197e-09 3.4700010 1.39614297e-09 3.4800000 1.39614297e-09 \
    3.4800010 0 3.5100000 0 3.5100010 -1.18884725e-09 3.5200000 -1.18884725e-09 \
    3.5200010 0 3.5300000 0 3.5300010 4.98261223e-10 3.5400000 4.98261223e-10 \
    3.5400010 0 3.5600000 0 3.5600010 -8.37667332e-10 3.5700000 -8.37667332e-10 \
    3.5700010 1.35433294e-09 3.5800000 1.35433294e-09 3.5800010 0 3.6100000 0 \
    3.6100010 -1.08053404e-09 3.6200000 -1.08053404e-09 3.6200010 1.19542153e-09 3.6300000 1.19542153e-09 \
    3.6300010 0 3.6600000 0 3.6600010 -7.57080415e-10 3.6700000 -7.57080415e-10 \
    3.6700010 1.28436173e-09 3.6800000 1.28436173e-09 3.6800010 0 3.7100000 0 \
    3.7100010 -1.11850239e-09 3.7200000 -1.11850239e-09 3.7200010 1.15190832e-10 3.7300000 1.15190832e-10 \
    3.7300010 1.26478677e-09 3.7400000 1.26478677e-09 3.7400010 0 3.7600000 0 \
    3.7600010 -9.4380648e-10 3.7700000 -9.4380648e-10 3.7700010 1.0597641e-09 3.7800000 1.0597641e-09 \
    3.7800010 0 3.8100000 0 3.8100010 -1.0843899e-09 3.8200000 -1.0843899e-09 \
    3.8200010 9.53263017e-10 3.8300000 9.53263017e-10 3.8300010 0 3.8600000 0 \
    3.8600010 -9.2206456e-10 3.8700000 -9.2206456e-10 3.8700010 1.40901673e-09 3.8800000 1.40901673e-09 \
    3.8800010 0 3.9100000 0 3.9100010 -8.9768475e-10 3.9200000 -8.9768475e-10 \
    3.9200010 1.20004431e-09 3.9300000 1.20004431e-09 3.9300010 0 3.9600000 0 \
    3.9600010 -9.87596313e-10 3.9700000 -9.87596313e-10 3.9700010 1.27236852e-09 3.9800000 1.27236852e-09 \
    3.9800010 -1.19993634e-09 3.9900000 -1.19993634e-09 3.9900010 1.18021614e-09 4.0000000 1.18021614e-09 \
    4.0000010 0 4.0600000 0 ]
Rsh14 (n_ig14 0) resistor r=1G

X15 (n_in 0 n_ig15 n_rm15) ecfet_v3 Rinit=1642.09131525 A_stdp=0
ig15 (0 n_ig15) isource type=pwl wave=[ 0.0000000 0 0.0200000 0 0.0200010 -1.16167311e-09 0.0300000 -1.16167311e-09 \
    0.0300010 9.02462232e-10 0.0400000 9.02462232e-10 0.0400010 0 0.0600000 0 \
    0.0600010 -1.18164879e-09 0.0700000 -1.18164879e-09 0.0700010 0 0.0800000 0 \
    0.0800010 9.28298473e-10 0.0900000 9.28298473e-10 0.0900010 0 0.1000000 0 \
    0.1000010 -1.03172092e-09 0.1100000 -1.03172092e-09 0.1100010 9.98440354e-10 0.1200000 9.98440354e-10 \
    0.1200010 -1.27681582e-09 0.1300000 -1.27681582e-09 0.1300010 5.57733669e-10 0.1400000 5.57733669e-10 \
    0.1400010 -1.13997825e-09 0.1500000 -1.13997825e-09 0.1500010 6.63617013e-10 0.1600000 6.63617013e-10 \
    0.1600010 0 0.1700000 0 0.1700010 -8.36864966e-10 0.1800000 -8.36864966e-10 \
    0.1800010 8.7350204e-10 0.1900000 8.7350204e-10 0.1900010 0 0.2200000 0 \
    0.2200010 -1.13701086e-09 0.2300000 -1.13701086e-09 0.2300010 9.25481825e-10 0.2400000 9.25481825e-10 \
    0.2400010 0 0.2700000 0 0.2700010 4.43761362e-10 0.2800000 4.43761362e-10 \
    0.2800010 0 0.3100000 0 0.3100010 -1.2594344e-09 0.3200000 -1.2594344e-09 \
    0.3200010 0 0.3300000 0 0.3300010 -3.66041126e-10 0.3400000 -3.66041126e-10 \
    0.3400010 1.25098526e-09 0.3500000 1.25098526e-09 0.3500010 -1.12064344e-09 0.3600000 -1.12064344e-09 \
    0.3600010 5.4127318e-10 0.3700000 5.4127318e-10 0.3700010 0 0.4000000 0 \
    0.4000010 -1.27707841e-09 0.4100000 -1.27707841e-09 0.4100010 0 0.4200000 0 \
    0.4200010 5.88892262e-11 0.4300000 5.88892262e-11 0.4300010 0 0.4400000 0 \
    0.4400010 6.07051222e-10 0.4500000 6.07051222e-10 0.4500010 5.77749753e-10 0.4600000 5.77749753e-10 \
    0.4600010 -1.06778428e-09 0.4700000 -1.06778428e-09 0.4700010 1.5823004e-10 0.4800000 1.5823004e-10 \
    0.4800010 0 0.4900000 0 0.4900010 6.7260468e-10 0.5000000 6.7260468e-10 \
    0.5000010 7.31415428e-12 0.5100000 7.31415428e-12 0.5100010 -1.1022584e-09 0.5200000 -1.1022584e-09 \
    0.5200010 -3.05153046e-10 0.5300000 -3.05153046e-10 0.5300010 1.49744217e-09 0.5400000 1.49744217e-09 \
    0.5400010 -9.3864526e-10 0.5500000 -9.3864526e-10 0.5500010 1.16460195e-09 0.5600000 1.16460195e-09 \
    0.5600010 -7.89964207e-10 0.5700000 -7.89964207e-10 0.5700010 0 0.5800000 0 \
    0.5800010 1.10050759e-09 0.5900000 1.10050759e-09 0.5900010 0 0.6000000 0 \
    0.6000010 -1.23635155e-09 0.6100000 -1.23635155e-09 0.6100010 -3.53205546e-10 0.6200000 -3.53205546e-10 \
    0.6200010 1.29776448e-09 0.6300000 1.29776448e-09 0.6300010 0 0.6700000 0 \
    0.6700010 7.75367669e-10 0.6800000 7.75367669e-10 0.6800010 -1.15773817e-09 0.6900000 -1.15773817e-09 \
    0.6900010 -5.4118852e-10 0.7000000 -5.4118852e-10 0.7000010 0 0.7100000 0 \
    0.7100010 6.40046233e-10 0.7200000 6.40046233e-10 0.7200010 -9.95880546e-10 0.7300000 -9.95880546e-10 \
    0.7300010 0 0.7400000 0 0.7400010 6.12527231e-10 0.7500000 6.12527231e-10 \
    0.7500010 0 0.7700000 0 0.7700010 7.14401785e-10 0.7800000 7.14401785e-10 \
    0.7800010 -1.16516818e-09 0.7900000 -1.16516818e-09 0.7900010 3.14261638e-11 0.8000000 3.14261638e-11 \
    0.8000010 0 0.8100000 0 0.8100010 -4.82495417e-10 0.8200000 -4.82495417e-10 \
    0.8200010 1.82583554e-10 0.8300000 1.82583554e-10 0.8300010 0 0.8400000 0 \
    0.8400010 -6.38040289e-10 0.8500000 -6.38040289e-10 0.8500010 0 0.8700000 0 \
    0.8700010 -7.37849916e-10 0.8800000 -7.37849916e-10 0.8800010 1.30689285e-09 0.8900000 1.30689285e-09 \
    0.8900010 4.77597539e-10 0.9000000 4.77597539e-10 0.9000010 0 0.9100000 0 \
    0.9100010 -7.3145034e-10 0.9200000 -7.3145034e-10 0.9200010 1.06677708e-09 0.9300000 1.06677708e-09 \
    0.9300010 0 0.9400000 0 0.9400010 5.87585567e-12 0.9500000 5.87585567e-12 \
    0.9500010 -1.29287368e-09 0.9600000 -1.29287368e-09 0.9600010 0 0.9700000 0 \
    0.9700010 -2.47773629e-10 0.9800000 -2.47773629e-10 0.9800010 3.56344797e-10 0.9900000 3.56344797e-10 \
    0.9900010 8.21581069e-11 1.0000000 8.21581069e-11 1.0000010 1.29554834e-11 1.0100000 1.29554834e-11 \
    1.0100010 1.36144174e-09 1.0200000 1.36144174e-09 1.0200010 4.56475703e-10 1.0300000 4.56475703e-10 \
    1.0300010 0 1.0400000 0 1.0400010 -1.19247037e-09 1.0500000 -1.19247037e-09 \
    1.0500010 0 1.0600000 0 1.0600010 9.15512266e-10 1.0700000 9.15512266e-10 \
    1.0700010 0 1.0900000 0 1.0900010 3.76291748e-10 1.1000000 3.76291748e-10 \
    1.1000010 -1.10641123e-09 1.1100000 -1.10641123e-09 1.1100010 1.49327155e-09 1.1200000 1.49327155e-09 \
    1.1200010 3.53304418e-11 1.1300000 3.53304418e-11 1.1300010 -9.5539538e-10 1.1400000 -9.5539538e-10 \
    1.1400010 9.40190612e-10 1.1500000 9.40190612e-10 1.1500010 5.08366101e-10 1.1600000 5.08366101e-10 \
    1.1600010 0 1.1700000 0 1.1700010 7.92304716e-10 1.1800000 7.92304716e-10 \
    1.1800010 0 1.2000000 0 1.2000010 -1.14162719e-09 1.2100000 -1.14162719e-09 \
    1.2100010 8.91071612e-10 1.2200000 8.91071612e-10 1.2200010 -8.39312541e-10 1.2300000 -8.39312541e-10 \
    1.2300010 1.10842997e-09 1.2400000 1.10842997e-09 1.2400010 0 1.2500000 0 \
    1.2500010 8.02128115e-10 1.2600000 8.02128115e-10 1.2600010 0 1.3000000 0 \
    1.3000010 3.90950114e-10 1.3100000 3.90950114e-10 1.3100010 0 1.3400000 0 \
    1.3400010 3.97634538e-10 1.3500000 3.97634538e-10 1.3500010 -1.02862294e-09 1.3600000 -1.02862294e-09 \
    1.3600010 1.14502208e-09 1.3700000 1.14502208e-09 1.3700010 0 1.4000000 0 \
    1.4000010 -1.22401028e-09 1.4100000 -1.22401028e-09 1.4100010 8.7279588e-10 1.4200000 8.7279588e-10 \
    1.4200010 0 1.4500000 0 1.4500010 -1.21930847e-09 1.4600000 -1.21930847e-09 \
    1.4600010 0 1.4700000 0 1.4700010 3.09727676e-10 1.4800000 3.09727676e-10 \
    1.4800010 8.91530442e-10 1.4900000 8.91530442e-10 1.4900010 0 1.5000000 0 \
    1.5000010 -1.19645594e-09 1.5100000 -1.19645594e-09 1.5100010 1.06016976e-09 1.5200000 1.06016976e-09 \
    1.5200010 0 1.5300000 0 1.5300010 -9.48412471e-10 1.5400000 -9.48412471e-10 \
    1.5400010 9.2614973e-10 1.5500000 9.2614973e-10 1.5500010 -8.02456651e-10 1.5600000 -8.02456651e-10 \
    1.5600010 -3.72527095e-10 1.5700000 -3.72527095e-10 1.5700010 0 1.5800000 0 \
    1.5800010 -2.13045092e-10 1.5900000 -2.13045092e-10 1.5900010 7.72626061e-10 1.6000000 7.72626061e-10 \
    1.6000010 3.85928052e-11 1.6100000 3.85928052e-11 1.6100010 -1.28598103e-09 1.6200000 -1.28598103e-09 \
    1.6200010 0 1.6300000 0 1.6300010 -6.13646223e-10 1.6400000 -6.13646223e-10 \
    1.6400010 9.77853147e-10 1.6500000 9.77853147e-10 1.6500010 0 1.6800000 0 \
    1.6800010 -1.26768125e-09 1.6900000 -1.26768125e-09 1.6900010 0 1.7000000 0 \
    1.7000010 4.67691033e-10 1.7100000 4.67691033e-10 1.7100010 0 1.7300000 0 \
    1.7300010 -9.57660186e-10 1.7400000 -9.57660186e-10 1.7400010 1.06665775e-09 1.7500000 1.06665775e-09 \
    1.7500010 0 1.7800000 0 1.7800010 5.60254764e-10 1.7900000 5.60254764e-10 \
    1.7900010 0 1.8300000 0 1.8300010 3.90098372e-10 1.8400000 3.90098372e-10 \
    1.8400010 0 1.8800000 0 1.8800010 -1.08695427e-09 1.8900000 -1.08695427e-09 \
    1.8900010 -2.77618487e-10 1.9000000 -2.77618487e-10 1.9000010 8.36198943e-10 1.9100000 8.36198943e-10 \
    1.9100010 0 1.9300000 0 1.9300010 3.95785443e-10 1.9400000 3.95785443e-10 \
    1.9400010 0 1.9800000 0 1.9800010 -1.23569032e-09 1.9900000 -1.23569032e-09 \
    1.9900010 8.66580975e-10 2.0000000 8.66580975e-10 2.0000010 0 2.0300000 0 \
    2.0300010 -9.12121331e-10 2.0400000 -9.12121331e-10 2.0400010 9.77982332e-10 2.0500000 9.77982332e-10 \
    2.0500010 6.32944292e-10 2.0600000 6.32944292e-10 2.0600010 0 2.0800000 0 \
    2.0800010 -9.89115899e-10 2.0900000 -9.89115899e-10 2.0900010 6.6693604e-10 2.1000000 6.6693604e-10 \
    2.1000010 -1.00610402e-09 2.1100000 -1.00610402e-09 2.1100010 2.07906372e-10 2.1200000 2.07906372e-10 \
    2.1200010 1.90940442e-10 2.1300000 1.90940442e-10 2.1300010 1.3718686e-09 2.1400000 1.3718686e-09 \
    2.1400010 -1.06103128e-09 2.1500000 -1.06103128e-09 2.1500010 1.38002806e-09 2.1600000 1.38002806e-09 \
    2.1600010 -1.20602402e-09 2.1700000 -1.20602402e-09 2.1700010 1.45965718e-10 2.1800000 1.45965718e-10 \
    2.1800010 -3.39800799e-10 2.1900000 -3.39800799e-10 2.1900010 -3.62860904e-10 2.2000000 -3.62860904e-10 \
    2.2000010 1.48610615e-09 2.2100000 1.48610615e-09 2.2100010 -1.08774277e-09 2.2200000 -1.08774277e-09 \
    2.2200010 6.78825968e-10 2.2300000 6.78825968e-10 2.2300010 0 2.2400000 0 \
    2.2400010 5.38105348e-10 2.2500000 5.38105348e-10 2.2500010 5.17898864e-10 2.2600000 5.17898864e-10 \
    2.2600010 0 2.2700000 0 2.2700010 5.12708566e-10 2.2800000 5.12708566e-10 \
    2.2800010 5.03014554e-10 2.2900000 5.03014554e-10 2.2900010 -9.36215871e-10 2.3000000 -9.36215871e-10 \
    2.3000010 1.0148296e-09 2.3100000 1.0148296e-09 2.3100010 0 2.3400000 0 \
    2.3400010 -1.03577436e-09 2.3500000 -1.03577436e-09 2.3500010 1.47113467e-09 2.3600000 1.47113467e-09 \
    2.3600010 0 2.3900000 0 2.3900010 4.87654997e-10 2.4000000 4.87654997e-10 \
    2.4000010 0 2.4200000 0 2.4200010 -1.29259078e-09 2.4300000 -1.29259078e-09 \
    2.4300010 1.06555113e-09 2.4400000 1.06555113e-09 2.4400010 2.69177346e-10 2.4500000 2.69177346e-10 \
    2.4500010 0 2.4600000 0 2.4600010 2.53302768e-10 2.4700000 2.53302768e-10 \
    2.4700010 0 2.4800000 0 2.4800010 -1.25088622e-09 2.4900000 -1.25088622e-09 \
    2.4900010 7.59678217e-10 2.5000000 7.59678217e-10 2.5000010 -8.47598082e-10 2.5100000 -8.47598082e-10 \
    2.5100010 1.13581523e-09 2.5200000 1.13581523e-09 2.5200010 -8.95674401e-10 2.5300000 -8.95674401e-10 \
    2.5300010 4.66978918e-10 2.5400000 4.66978918e-10 2.5400010 1.00371426e-09 2.5500000 1.00371426e-09 \
    2.5500010 -7.10064305e-10 2.5600000 -7.10064305e-10 2.5600010 0 2.5700000 0 \
    2.5700010 -1.8519297e-10 2.5800000 -1.8519297e-10 2.5800010 1.09258461e-09 2.5900000 1.09258461e-09 \
    2.5900010 0 2.6000000 0 2.6000010 1.77693403e-10 2.6100000 1.77693403e-10 \
    2.6100010 -7.89953959e-10 2.6200000 -7.89953959e-10 2.6200010 -9.77675128e-11 2.6300000 -9.77675128e-11 \
    2.6300010 0 2.6400000 0 2.6400010 -5.85259561e-10 2.6500000 -5.85259561e-10 \
    2.6500010 1.35522908e-10 2.6600000 1.35522908e-10 2.6600010 7.28659191e-10 2.6700000 7.28659191e-10 \
    2.6700010 0 2.7000000 0 2.7000010 -1.22657485e-09 2.7100000 -1.22657485e-09 \
    2.7100010 9.39064485e-10 2.7200000 9.39064485e-10 2.7200010 0 2.7500000 0 \
    2.7500010 -9.58541524e-10 2.7600000 -9.58541524e-10 2.7600010 0 2.7700000 0 \
    2.7700010 -6.61243959e-10 2.7800000 -6.61243959e-10 2.7800010 8.92674689e-10 2.7900000 8.92674689e-10 \
    2.7900010 0 2.8300000 0 2.8300010 -1.22487224e-09 2.8400000 -1.22487224e-09 \
    2.8400010 8.35995247e-10 2.8500000 8.35995247e-10 2.8500010 0 2.8800000 0 \
    2.8800010 4.89346974e-10 2.8900000 4.89346974e-10 2.8900010 2.37644434e-10 2.9000000 2.37644434e-10 \
    2.9000010 0 2.9300000 0 2.9300010 -7.63731055e-10 2.9400000 -7.63731055e-10 \
    2.9400010 8.62228455e-10 2.9500000 8.62228455e-10 2.9500010 0 2.9700000 0 \
    2.9700010 4.30210387e-10 2.9800000 4.30210387e-10 2.9800010 -1.12406359e-09 2.9900000 -1.12406359e-09 \
    2.9900010 8.30755209e-10 3.0000000 8.30755209e-10 3.0000010 0 3.0300000 0 \
    3.0300010 -1.20152756e-09 3.0400000 -1.20152756e-09 3.0400010 8.08996478e-10 3.0500000 8.08996478e-10 \
    3.0500010 0 3.0800000 0 3.0800010 -1.28795339e-09 3.0900000 -1.28795339e-09 \
    3.0900010 0 3.1000000 0 3.1000010 3.61330476e-10 3.1100000 3.61330476e-10 \
    3.1100010 0 3.1300000 0 3.1300010 -1.26845471e-09 3.1400000 -1.26845471e-09 \
    3.1400010 7.00186167e-10 3.1500000 7.00186167e-10 3.1500010 0 3.1700000 0 \
    3.1700010 -1.04675294e-09 3.1800000 -1.04675294e-09 3.1800010 1.28091083e-09 3.1900000 1.28091083e-09 \
    3.1900010 0 3.2300000 0 3.2300010 2.50272068e-10 3.2400000 2.50272068e-10 \
    3.2400010 0 3.2800000 0 3.2800010 -1.21464165e-09 3.2900000 -1.21464165e-09 \
    3.2900010 5.77404465e-10 3.3000000 5.77404465e-10 3.3000010 0 3.3300000 0 \
    3.3300010 -1.29396941e-09 3.3400000 -1.29396941e-09 3.3400010 1.42868784e-09 3.3500000 1.42868784e-09 \
    3.3500010 0 3.3600000 0 3.3600010 -8.83326854e-10 3.3700000 -8.83326854e-10 \
    3.3700010 1.49990858e-09 3.3800000 1.49990858e-09 3.3800010 -5.11890665e-10 3.3900000 -5.11890665e-10 \
    3.3900010 7.73972956e-10 3.4000000 7.73972956e-10 3.4000010 -1.13510594e-09 3.4100000 -1.13510594e-09 \
    3.4100010 1.08521638e-09 3.4200000 1.08521638e-09 3.4200010 3.95503162e-10 3.4300000 3.95503162e-10 \
    3.4300010 0 3.4600000 0 3.4600010 -7.40250144e-10 3.4700000 -7.40250144e-10 \
    3.4700010 6.1181234e-11 3.4800000 6.1181234e-11 3.4800010 5.67444504e-10 3.4900000 5.67444504e-10 \
    3.4900010 0 3.5000000 0 3.5000010 -1.21867544e-09 3.5100000 -1.21867544e-09 \
    3.5100010 8.24673506e-10 3.5200000 8.24673506e-10 3.5200010 -1.11522122e-09 3.5300000 -1.11522122e-09 \
    3.5300010 2.48449932e-10 3.5400000 2.48449932e-10 3.5400010 -1.39804479e-10 3.5500000 -1.39804479e-10 \
    3.5500010 1.22758576e-09 3.5600000 1.22758576e-09 3.5600010 -9.39458756e-10 3.5700000 -9.39458756e-10 \
    3.5700010 1.3922101e-09 3.5800000 1.3922101e-09 3.5800010 0 3.5900000 0 \
    3.5900010 -1.27324511e-09 3.6000000 -1.27324511e-09 3.6000010 1.32249099e-10 3.6100000 1.32249099e-10 \
    3.6100010 0 3.6200000 0 3.6200010 -3.37088242e-10 3.6300000 -3.37088242e-10 \
    3.6300010 9.39082316e-10 3.6400000 9.39082316e-10 3.6400010 -1.08738996e-09 3.6500000 -1.08738996e-09 \
    3.6500010 -1.58777979e-10 3.6600000 -1.58777979e-10 3.6600010 0 3.6700000 0 \
    3.6700010 -3.08247094e-10 3.6800000 -3.08247094e-10 3.6800010 1.17330522e-09 3.6900000 1.17330522e-09 \
    3.6900010 3.55418896e-10 3.7000000 3.55418896e-10 3.7000010 -9.22817149e-10 3.7100000 -9.22817149e-10 \
    3.7100010 1.0634237e-09 3.7200000 1.0634237e-09 3.7200010 0 3.7500000 0 \
    3.7500010 4.05579895e-10 3.7600000 4.05579895e-10 3.7600010 0 3.7900000 0 \
    3.7900010 7.39068871e-11 3.8000000 7.39068871e-11 3.8000010 -9.92572766e-10 3.8100000 -9.92572766e-10 \
    3.8100010 1.07259756e-09 3.8200000 1.07259756e-09 3.8200010 0 3.8500000 0 \
    3.8500010 -1.28439634e-09 3.8600000 -1.28439634e-09 3.8600010 0 3.8700000 0 \
    3.8700010 7.2474281e-10 3.8800000 7.2474281e-10 3.8800010 0 3.9000000 0 \
    3.9000010 -1.22871617e-09 3.9100000 -1.22871617e-09 3.9100010 0 3.9200000 0 \
    3.9200010 6.39337761e-10 3.9300000 6.39337761e-10 3.9300010 0 3.9500000 0 \
    3.9500010 2.94492093e-10 3.9600000 2.94492093e-10 3.9600010 0 4.0000000 0 \
    4.0000010 -1.08716599e-09 4.0100000 -1.08716599e-09 4.0100010 0 4.0600000 0 ]
Rsh15 (n_ig15 0) resistor r=1G

tran tran stop=4.06 maxstep=0.001 errpreset=conservative ic=node strobeperiod=0.0002

save n_rm0 X0.n_x X0:IGsc n_rm1 X1.n_x X1:IGsc n_rm2 X2.n_x X2:IGsc n_rm3 X3.n_x X3:IGsc n_rm4 X4.n_x X4:IGsc n_rm5 X5.n_x X5:IGsc n_rm6 X6.n_x X6:IGsc n_rm7 X7.n_x X7:IGsc n_rm8 X8.n_x X8:IGsc n_rm9 X9.n_x X9:IGsc n_rm10 X10.n_x X10:IGsc n_rm11 X11.n_x X11:IGsc n_rm12 X12.n_x X12:IGsc n_rm13 X13.n_x X13:IGsc n_rm14 X14.n_x X14:IGsc n_rm15 X15.n_x X15:IGsc
