// amplitude_sweep.scs - GENERATED by validation/stanford/make_decks.py; do not edit.
// stanford-1 validation deck: Stanford-PKU RRAM v1.0.0 (rram_v_1_0_0) under 'amplitude_sweep'
//   from LRS: 10 ns RESET pulses of -1.0/-1.1/-1.2/-1.3/-1.4 V, then 10 ns SET pulses of +1.0..+1.4 V, each followed by a read
// stimulus set stanford-1 (158bdb6aa16bc5f0), t_stop 2.065e-07 s,
// 10 read plateau(s) at 0.1 V
//
// Model: Stanford Nanoelectronics Research Group (Prof. H.-S. Philip Wong);
// Z. Jiang et al., IEEE TED 63(5), 2016; nanoHUB doi:10.4231/D37H1DN48.
//
// Run (writes amplitude_sweep.raw/tran.tran in PSF-ascii):
//   spectre +escchars -format psfascii -raw amplitude_sweep.raw +log amplitude_sweep.log amplitude_sweep.scs
// then import with validation/stanford/scrub.py (see validation/README.md).

simulator lang=spectre
global 0

ahdl_include "../../../verilog/stanford_pku_rram_spectre.va"

simOpts options reltol=1e-5 vabstol=1e-9 iabstol=1e-15 gmin=1e-15
saveOpts options save=selected

// DUT: module rram_v_1_0_0(TE, BE); parameters = twin defaults, q/kb explicit,
// time_step ($bound_step) = maxstep
X1 (n_te 0) rram_v_1_0_0 model_switch=0 q=1.602176462e-19 kb=1.3806503e-23 time_step=1e-10

// V(TE,BE): PWL with exactly the twin's points
vte (n_te 0) vsource type=pwl wave=[ 0 0 1e-09 0 1.05e-09 -1 1.1e-08 -1 \
    1.105e-08 0 1.405e-08 0 1.41e-08 0.1 1.805e-08 0.1 \
    1.81e-08 0 2.105e-08 0 2.11e-08 -1.1 3.105e-08 -1.1 \
    3.11e-08 0 3.41e-08 0 3.415e-08 0.1 3.81e-08 0.1 \
    3.815e-08 0 4.11e-08 0 4.115e-08 -1.2 5.11e-08 -1.2 \
    5.115e-08 0 5.415e-08 0 5.42e-08 0.1 5.815e-08 0.1 \
    5.82e-08 0 6.115e-08 0 6.12e-08 -1.3 7.115e-08 -1.3 \
    7.12e-08 0 7.42e-08 0 7.425e-08 0.1 7.82e-08 0.1 \
    7.825e-08 0 8.12e-08 0 8.125e-08 -1.4 9.12e-08 -1.4 \
    9.125e-08 0 9.425e-08 0 9.43e-08 0.1 9.825e-08 0.1 \
    9.83e-08 0 1.0125e-07 0 1.013e-07 1 1.1125e-07 1 \
    1.113e-07 0 1.143e-07 0 1.1435e-07 0.1 1.183e-07 0.1 \
    1.1835e-07 0 1.213e-07 0 1.2135e-07 1.1 1.313e-07 1.1 \
    1.3135e-07 0 1.3435e-07 0 1.344e-07 0.1 1.3835e-07 0.1 \
    1.384e-07 0 1.4135e-07 0 1.414e-07 1.2 1.5135e-07 1.2 \
    1.514e-07 0 1.544e-07 0 1.5445e-07 0.1 1.584e-07 0.1 \
    1.5845e-07 0 1.614e-07 0 1.6145e-07 1.3 1.714e-07 1.3 \
    1.7145e-07 0 1.7445e-07 0 1.745e-07 0.1 1.7845e-07 0.1 \
    1.785e-07 0 1.8145e-07 0 1.815e-07 1.4 1.9145e-07 1.4 \
    1.915e-07 0 1.945e-07 0 1.9455e-07 0.1 1.985e-07 0.1 \
    1.9855e-07 0 2.015e-07 0 2.065e-07 0 ]

tran tran stop=2.065e-07 maxstep=1e-10 errpreset=conservative

save n_te X1:TE vte:p
