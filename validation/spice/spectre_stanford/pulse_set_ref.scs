// pulse_set_ref.scs - GENERATED by validation/stanford/make_decks.py; do not edit.
// stanford-1 validation deck: Stanford-PKU RRAM v1.0.0 (rram_v_1_0_0) under 'pulse_set_ref'
//   HSPICE template pulseSweep.sp SET: +1.8 V / 100 ns from HRS (gap_ini 1.9 nm > gap_max), 10 ps edges, then a 0.1 V / 40 ns read
// stimulus set stanford-1 (158bdb6aa16bc5f0), t_stop 2.0501e-07 s,
// 1 read plateau(s) at 0.1 V
//
// Model: Stanford Nanoelectronics Research Group (Prof. H.-S. Philip Wong);
// Z. Jiang et al., IEEE TED 63(5), 2016; nanoHUB doi:10.4231/D37H1DN48.
//
// Run (writes pulse_set_ref.raw/tran.tran in PSF-ascii):
//   spectre +escchars -format psfascii -raw pulse_set_ref.raw +log pulse_set_ref.log pulse_set_ref.scs
// then import with validation/stanford/scrub.py (see validation/README.md).

simulator lang=spectre
global 0

ahdl_include "../../../verilog/stanford_pku_rram_spectre.va"

simOpts options reltol=1e-5 vabstol=1e-9 iabstol=1e-15 gmin=1e-15
saveOpts options save=selected

// DUT: module rram_v_1_0_0(TE, BE); parameters = twin defaults, q/kb explicit,
// time_step ($bound_step) = maxstep
X1 (n_te 0) rram_v_1_0_0 model_switch=0 q=1.602176462e-19 kb=1.3806503e-23 time_step=1e-10 gap_ini=1.9e-09

// V(TE,BE): PWL with exactly the twin's points
vte (n_te 0) vsource type=pwl wave=[ 0 0 1e-11 0 2e-11 1.8 1.0001e-07 1.8 \
    1.0002e-07 0 1.5001e-07 0 1.5006e-07 0.1 1.9001e-07 0.1 \
    1.9006e-07 0 2.0501e-07 0 ]

tran tran stop=2.0501e-07 maxstep=1e-10 errpreset=conservative

save n_te X1:TE vte:p
