// read_disturb_hold.scs - GENERATED by validation/stanford/make_decks.py; do not edit.
// stanford-1 validation deck: Stanford-PKU RRAM v1.0.0 (rram_v_1_0_0) under 'read_disturb_hold'
//   5 x -1.3 V / 10 ns from LRS, read, 1 us hold at 0 V, read, then 10 x 5 ns stress pulses at 0.1/0.5/0.9/+1.2/-1.2 V, each group followed by a 0.1 V read
// stimulus set stanford-1 (158bdb6aa16bc5f0), t_stop 1.65385e-06 s,
// 7 read plateau(s) at 0.1 V
//
// Model: Stanford Nanoelectronics Research Group (Prof. H.-S. Philip Wong);
// Z. Jiang et al., IEEE TED 63(5), 2016; nanoHUB doi:10.4231/D37H1DN48.
//
// Run (writes read_disturb_hold.raw/tran.tran in PSF-ascii):
//   spectre +escchars -format psfascii -raw read_disturb_hold.raw +log read_disturb_hold.log read_disturb_hold.scs
// then import with validation/stanford/scrub.py (see validation/README.md).

simulator lang=spectre
global 0

ahdl_include "../../../verilog/stanford_pku_rram_spectre.va"

simOpts options reltol=1e-5 vabstol=1e-9 iabstol=1e-15 gmin=1e-15
saveOpts options save=selected

// DUT: module rram_v_1_0_0(TE, BE); parameters = twin defaults, q/kb explicit,
// time_step ($bound_step) = maxstep
X1 (n_te 0) rram_v_1_0_0 model_switch=0 q=1.602176462e-19 kb=1.3806503e-23 time_step=1e-10

// V(TE,BE): PWL with exactly the twin's points
vte (n_te 0) vsource type=pwl wave=[ 0 0 1e-09 0 1.05e-09 -1.3 1.1e-08 -1.3 \
    1.105e-08 0 2.1e-08 0 2.105e-08 -1.3 3.1e-08 -1.3 \
    3.105e-08 0 4.1e-08 0 4.105e-08 -1.3 5.1e-08 -1.3 \
    5.105e-08 0 6.1e-08 0 6.105e-08 -1.3 7.1e-08 -1.3 \
    7.105e-08 0 8.1e-08 0 8.105e-08 -1.3 9.1e-08 -1.3 \
    9.105e-08 0 1.01e-07 0 1.02e-07 0 1.0205e-07 0.1 \
    1.06e-07 0.1 1.0605e-07 0 1.10605e-06 0 1.10705e-06 0 \
    1.1071e-06 0.1 1.11105e-06 0.1 1.1111e-06 0 1.1161e-06 0 \
    1.11615e-06 0.1 1.1211e-06 0.1 1.12115e-06 0 1.12615e-06 0 \
    1.1262e-06 0.1 1.13115e-06 0.1 1.1312e-06 0 1.1362e-06 0 \
    1.13625e-06 0.1 1.1412e-06 0.1 1.14125e-06 0 1.14625e-06 0 \
    1.1463e-06 0.1 1.15125e-06 0.1 1.1513e-06 0 1.1563e-06 0 \
    1.15635e-06 0.1 1.1613e-06 0.1 1.16135e-06 0 1.16635e-06 0 \
    1.1664e-06 0.1 1.17135e-06 0.1 1.1714e-06 0 1.1764e-06 0 \
    1.17645e-06 0.1 1.1814e-06 0.1 1.18145e-06 0 1.18645e-06 0 \
    1.1865e-06 0.1 1.19145e-06 0.1 1.1915e-06 0 1.1965e-06 0 \
    1.19655e-06 0.1 1.2015e-06 0.1 1.20155e-06 0 1.20655e-06 0 \
    1.2066e-06 0.1 1.21155e-06 0.1 1.2116e-06 0 1.2146e-06 0 \
    1.21465e-06 0.1 1.2186e-06 0.1 1.21865e-06 0 1.22365e-06 0 \
    1.2237e-06 0.5 1.22865e-06 0.5 1.2287e-06 0 1.2337e-06 0 \
    1.23375e-06 0.5 1.2387e-06 0.5 1.23875e-06 0 1.24375e-06 0 \
    1.2438e-06 0.5 1.24875e-06 0.5 1.2488e-06 0 1.2538e-06 0 \
    1.25385e-06 0.5 1.2588e-06 0.5 1.25885e-06 0 1.26385e-06 0 \
    1.2639e-06 0.5 1.26885e-06 0.5 1.2689e-06 0 1.2739e-06 0 \
    1.27395e-06 0.5 1.2789e-06 0.5 1.27895e-06 0 1.28395e-06 0 \
    1.284e-06 0.5 1.28895e-06 0.5 1.289e-06 0 1.294e-06 0 \
    1.29405e-06 0.5 1.299e-06 0.5 1.29905e-06 0 1.30405e-06 0 \
    1.3041e-06 0.5 1.30905e-06 0.5 1.3091e-06 0 1.3141e-06 0 \
    1.31415e-06 0.5 1.3191e-06 0.5 1.31915e-06 0 1.32215e-06 0 \
    1.3222e-06 0.1 1.32615e-06 0.1 1.3262e-06 0 1.3312e-06 0 \
    1.33125e-06 0.9 1.3362e-06 0.9 1.33625e-06 0 1.34125e-06 0 \
    1.3413e-06 0.9 1.34625e-06 0.9 1.3463e-06 0 1.3513e-06 0 \
    1.35135e-06 0.9 1.3563e-06 0.9 1.35635e-06 0 1.36135e-06 0 \
    1.3614e-06 0.9 1.36635e-06 0.9 1.3664e-06 0 1.3714e-06 0 \
    1.37145e-06 0.9 1.3764e-06 0.9 1.37645e-06 0 1.38145e-06 0 \
    1.3815e-06 0.9 1.38645e-06 0.9 1.3865e-06 0 1.3915e-06 0 \
    1.39155e-06 0.9 1.3965e-06 0.9 1.39655e-06 0 1.40155e-06 0 \
    1.4016e-06 0.9 1.40655e-06 0.9 1.4066e-06 0 1.4116e-06 0 \
    1.41165e-06 0.9 1.4166e-06 0.9 1.41665e-06 0 1.42165e-06 0 \
    1.4217e-06 0.9 1.42665e-06 0.9 1.4267e-06 0 1.4297e-06 0 \
    1.42975e-06 0.1 1.4337e-06 0.1 1.43375e-06 0 1.43875e-06 0 \
    1.4388e-06 1.2 1.44375e-06 1.2 1.4438e-06 0 1.4488e-06 0 \
    1.44885e-06 1.2 1.4538e-06 1.2 1.45385e-06 0 1.45885e-06 0 \
    1.4589e-06 1.2 1.46385e-06 1.2 1.4639e-06 0 1.4689e-06 0 \
    1.46895e-06 1.2 1.4739e-06 1.2 1.47395e-06 0 1.47895e-06 0 \
    1.479e-06 1.2 1.48395e-06 1.2 1.484e-06 0 1.489e-06 0 \
    1.48905e-06 1.2 1.494e-06 1.2 1.49405e-06 0 1.49905e-06 0 \
    1.4991e-06 1.2 1.50405e-06 1.2 1.5041e-06 0 1.5091e-06 0 \
    1.50915e-06 1.2 1.5141e-06 1.2 1.51415e-06 0 1.51915e-06 0 \
    1.5192e-06 1.2 1.52415e-06 1.2 1.5242e-06 0 1.5292e-06 0 \
    1.52925e-06 1.2 1.5342e-06 1.2 1.53425e-06 0 1.53725e-06 0 \
    1.5373e-06 0.1 1.54125e-06 0.1 1.5413e-06 0 1.5463e-06 0 \
    1.54635e-06 -1.2 1.5513e-06 -1.2 1.55135e-06 0 1.55635e-06 0 \
    1.5564e-06 -1.2 1.56135e-06 -1.2 1.5614e-06 0 1.5664e-06 0 \
    1.56645e-06 -1.2 1.5714e-06 -1.2 1.57145e-06 0 1.57645e-06 0 \
    1.5765e-06 -1.2 1.58145e-06 -1.2 1.5815e-06 0 1.5865e-06 0 \
    1.58655e-06 -1.2 1.5915e-06 -1.2 1.59155e-06 0 1.59655e-06 0 \
    1.5966e-06 -1.2 1.60155e-06 -1.2 1.6016e-06 0 1.6066e-06 0 \
    1.60665e-06 -1.2 1.6116e-06 -1.2 1.61165e-06 0 1.61665e-06 0 \
    1.6167e-06 -1.2 1.62165e-06 -1.2 1.6217e-06 0 1.6267e-06 0 \
    1.62675e-06 -1.2 1.6317e-06 -1.2 1.63175e-06 0 1.63675e-06 0 \
    1.6368e-06 -1.2 1.64175e-06 -1.2 1.6418e-06 0 1.6448e-06 0 \
    1.64485e-06 0.1 1.6488e-06 0.1 1.64885e-06 0 1.65385e-06 0 ]

tran tran stop=1.65385e-06 maxstep=1e-10 errpreset=conservative

save n_te X1:TE vte:p
