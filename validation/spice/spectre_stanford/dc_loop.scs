// dc_loop.scs - GENERATED by validation/stanford/make_decks.py; do not edit.
// stanford-1 validation deck: Stanford-PKU RRAM v1.0.0 (rram_v_1_0_0) under 'dc_loop'
//   two bipolar triangle loops in one transient, 1 V/us, from LRS: 0 -> -1.35 -> 0 -> +1.5 -> 0 V (x2)
// stimulus set stanford-1 (158bdb6aa16bc5f0), t_stop 1.15001e-05 s,
// 0 read plateau(s) at 0.1 V
//
// Model: Stanford Nanoelectronics Research Group (Prof. H.-S. Philip Wong);
// Z. Jiang et al., IEEE TED 63(5), 2016; nanoHUB doi:10.4231/D37H1DN48.
//
// Run (writes dc_loop.raw/tran.tran in PSF-ascii):
//   spectre +escchars -format psfascii -raw dc_loop.raw +log dc_loop.log dc_loop.scs
// then import with validation/stanford/scrub.py (see validation/README.md).

simulator lang=spectre
global 0

ahdl_include "../../../verilog/stanford_pku_rram_spectre.va"

simOpts options reltol=1e-5 vabstol=1e-9 iabstol=1e-15 gmin=1e-15
saveOpts options save=selected

// DUT: module rram_v_1_0_0(TE, BE); parameters = twin defaults, q/kb explicit,
// time_step ($bound_step) = maxstep
X1 (n_te 0) rram_v_1_0_0 model_switch=0 q=1.602176462e-19 kb=1.3806503e-23 time_step=1e-09

// V(TE,BE): PWL with exactly the twin's points
vte (n_te 0) vsource type=pwl wave=[ 0 0 1e-10 0 1.3501e-06 -1.35 2.7001e-06 0 \
    4.2001e-06 1.5 5.7001e-06 0 7.0501e-06 -1.35 8.4001e-06 0 \
    9.9001e-06 1.5 1.14001e-05 0 1.15001e-05 0 ]

tran tran stop=1.15001e-05 maxstep=1e-09 errpreset=conservative

save n_te X1:TE vte:p
