// dc_set_ref.scs - GENERATED by validation/stanford/make_decks.py; do not edit.
// stanford-1 validation deck: Stanford-PKU RRAM v1.0.0 (rram_v_1_0_0) under 'dc_set_ref'
//   HSPICE template DCSweep.sp SET (HRS start, gap_ini 1.9 nm): 0 -> +2 V -> 0 in 4 ms + 4 ms (0.5 V/ms) after 1 us; one half-sweep per transient, as the template does
// stimulus set stanford-1 (158bdb6aa16bc5f0), t_stop 0.0081 s,
// 0 read plateau(s) at 0.1 V
//
// Model: Stanford Nanoelectronics Research Group (Prof. H.-S. Philip Wong);
// Z. Jiang et al., IEEE TED 63(5), 2016; nanoHUB doi:10.4231/D37H1DN48.
//
// Run (writes dc_set_ref.raw/tran.tran in PSF-ascii):
//   spectre +escchars -format psfascii -raw dc_set_ref.raw +log dc_set_ref.log dc_set_ref.scs
// then import with validation/stanford/scrub.py (see validation/README.md).

simulator lang=spectre
global 0

ahdl_include "../../../verilog/stanford_pku_rram_spectre.va"

simOpts options reltol=1e-5 vabstol=1e-9 iabstol=1e-15 gmin=1e-15
saveOpts options save=selected

// DUT: module rram_v_1_0_0(TE, BE); parameters = twin defaults, q/kb explicit,
// time_step ($bound_step) = maxstep
X1 (n_te 0) rram_v_1_0_0 model_switch=0 q=1.602176462e-19 kb=1.3806503e-23 time_step=1e-06 gap_ini=1.9e-09

// V(TE,BE): PWL with exactly the twin's points
vte (n_te 0) vsource type=pwl wave=[ 0 0 1e-06 0 0.004001 2 0.004002 2 \
    0.008002 0 0.0081 0 ]

tran tran stop=0.0081 maxstep=1e-06 errpreset=conservative

save n_te X1:TE vte:p
