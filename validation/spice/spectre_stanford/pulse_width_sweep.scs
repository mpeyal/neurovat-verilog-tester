// pulse_width_sweep.scs - GENERATED by validation/stanford/make_decks.py; do not edit.
// stanford-1 validation deck: Stanford-PKU RRAM v1.0.0 (rram_v_1_0_0) under 'pulse_width_sweep'
//   from LRS: -1.3 V RESET pulses of 1/2/5/10/20 ns, then +1.35 V SET pulses of 1/2/5/10/20 ns, each followed by a read
// stimulus set stanford-1 (158bdb6aa16bc5f0), t_stop 1.825e-07 s,
// 10 read plateau(s) at 0.1 V
//
// Model: Stanford Nanoelectronics Research Group (Prof. H.-S. Philip Wong);
// Z. Jiang et al., IEEE TED 63(5), 2016; nanoHUB doi:10.4231/D37H1DN48.
//
// Run (writes pulse_width_sweep.raw/tran.tran in PSF-ascii):
//   spectre +escchars -format psfascii -raw pulse_width_sweep.raw +log pulse_width_sweep.log pulse_width_sweep.scs
// then import with validation/stanford/scrub.py (see validation/README.md).

simulator lang=spectre
global 0

ahdl_include "../../../verilog/stanford_pku_rram_spectre.va"

simOpts options reltol=1e-5 vabstol=1e-9 iabstol=1e-15 gmin=1e-15
saveOpts options save=selected

// DUT: module rram_v_1_0_0(TE, BE); parameters = twin defaults, q/kb explicit,
// time_step ($bound_step) = maxstep
X1 (n_te 0) rram_v_1_0_0 model_switch=0 q=1.602176462e-19 kb=1.3806503e-23 time_step=1e-10

// V(TE,BE): PWL with exactly the twin's points
vte (n_te 0) vsource type=pwl wave=[ 0 0 1e-09 0 1.05e-09 -1.3 2e-09 -1.3 \
    2.05e-09 0 5.05e-09 0 5.1e-09 0.1 9.05e-09 0.1 \
    9.1e-09 0 1.205e-08 0 1.21e-08 -1.3 1.405e-08 -1.3 \
    1.41e-08 0 1.71e-08 0 1.715e-08 0.1 2.11e-08 0.1 \
    2.115e-08 0 2.41e-08 0 2.415e-08 -1.3 2.91e-08 -1.3 \
    2.915e-08 0 3.215e-08 0 3.22e-08 0.1 3.615e-08 0.1 \
    3.62e-08 0 3.915e-08 0 3.92e-08 -1.3 4.915e-08 -1.3 \
    4.92e-08 0 5.22e-08 0 5.225e-08 0.1 5.62e-08 0.1 \
    5.625e-08 0 5.92e-08 0 5.925e-08 -1.3 7.92e-08 -1.3 \
    7.925e-08 0 8.225e-08 0 8.23e-08 0.1 8.625e-08 0.1 \
    8.63e-08 0 8.925e-08 0 8.93e-08 1.35 9.025e-08 1.35 \
    9.03e-08 0 9.33e-08 0 9.335e-08 0.1 9.73e-08 0.1 \
    9.735e-08 0 1.003e-07 0 1.0035e-07 1.35 1.023e-07 1.35 \
    1.0235e-07 0 1.0535e-07 0 1.054e-07 0.1 1.0935e-07 0.1 \
    1.094e-07 0 1.1235e-07 0 1.124e-07 1.35 1.1735e-07 1.35 \
    1.174e-07 0 1.204e-07 0 1.2045e-07 0.1 1.244e-07 0.1 \
    1.2445e-07 0 1.274e-07 0 1.2745e-07 1.35 1.374e-07 1.35 \
    1.3745e-07 0 1.4045e-07 0 1.405e-07 0.1 1.4445e-07 0.1 \
    1.445e-07 0 1.4745e-07 0 1.475e-07 1.35 1.6745e-07 1.35 \
    1.675e-07 0 1.705e-07 0 1.7055e-07 0.1 1.745e-07 0.1 \
    1.7455e-07 0 1.775e-07 0 1.825e-07 0 ]

tran tran stop=1.825e-07 maxstep=1e-10 errpreset=conservative

save n_te X1:TE vte:p
