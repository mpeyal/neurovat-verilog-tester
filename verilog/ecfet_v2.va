// ecfet_v2.va - upgraded practical ECFET / ECRAM model
//
// Drop-in replacement for basic_v1_Diffu_Drft_verilog with the same pins.
// Identical dynamics to the Python reference model (simulation_core/model_v2.py);
// tune parameters in Python first, then copy them here.
//
// Improvements over v1:
//  * Charge-controlled conductance update with exponential soft-bound
//    windows (NeuroSim-style nu_p / nu_d nonlinearity) - no hard clamps,
//    no switch-branch V()/I() mixing, so Spectre convergence is clean.
//  * Volatile relaxation proportional to the written dG: a fraction
//    kappa_v of every write lands in three relaxation pools with
//    tau1 = w^2/2D, tau2 = l^2/2D, tau3 - replaces v1's fixed
//    (c1+c2+c3)-ohm post-pulse jump and its hard 1 s cutoff.
//  * Long-term retention drift of the nonvolatile state toward R_eq.
//  * All state lives on internal nodes (1 V == 1 S), integrated by the
//    simulator itself, so timestep control and backtracking are exact.
//
// Defaults matched to the electrochemical graphene synapse of M. T. Sharbati
// et al., Adv. Mater. 2018, 30, 1802353 ("Low-Power, Electrochemically
// Tunable Graphene Synapses for Neuromorphic Computing").
//
// Sign convention (paper): a POSITIVE (intercalation) gate current
// POTENTIATES - it raises G and LOWERS R (polarity=-1).  A negative
// (deintercalation) current depresses.  This is the OPPOSITE of the legacy
// v1 .va; set polarity=+1 for the old sign.
//
// Default parameters reproduce the paper:
//   Fig. 3a) +50 pA / 10 ms pulse at R~4410 ohm: instantaneous dR=-30 ohm
//      (-0.67%) relaxing to a retained dR'=-10 ohm (-0.22%).
//   Fig. 3b) deintercalation pulse: mirror image, +30 ohm relaxing to +10 ohm.
//   Fig. 3c) LTP/LTD over G ~100..1150 uS in >250 near-linear states (R^2=0.994).
//   Fig. 4b) volatile relaxation with measured tau1=22 ms, tau2=315 ms
//      (in-plane diffusion, tau ~ L^2/2D) and tau3=19 s (LFP<->graphene).
//   Retention: 3.2% G loss over 13 h from the fully-charged (high-G) state
//      -> tau_retention ~ 1.31e6 s (lower-charge states drift less).
//
// dG per unit pulse: a pulse carrying Q_ref coulombs (= 50 pA x 10 ms here)
// moves G by ~dG_unit*window where dG_unit = (Gmax-Gmin)/n_states.

`include "constants.vams"
`include "disciplines.vams"

module ecfet_v2(In, Out, IGsc, Rmem);
output Rmem;
inout In, Out;
input IGsc;

electrical In, Out, IGsc, Rmem;
electrical n_nv, n_v1, n_v2, n_v3, ignd;   // state nodes: 1 V == 1 S
electrical n_stdp;   // STDP-only readout: V(n_stdp) = locked-in STDP weight (1 V == 1 S)

branch (In,Out) mem;

// DEFAULTS = PAPER config (Sharbati 2018): reproduces Fig.3a (50 pA pulse at
// 4400 ohm: dR -30 -> -10), Fig.3c (triangular LTP/LTD over 100..1150 uS), and
// Fig.4b STDP.  For the alternate 500 ohm single-spike demo use the [demo]
// values in comments (Rmin=400, Rinit=500, n_states=17, nu_d=0.58, c3=0) - but
// 500 ohm is outside the 100..1150 uS window so Fig.3c clips there.

// resistance range (Fig. 3c: G ~ 100..1150 uS)
parameter real Rmin  = 870  from (0:inf);     // -> Gmax ~ 1150 uS   [demo 400]
parameter real Rmax  = 10k  from (0:inf);     // -> Gmin = 100 uS    [demo 8333]
parameter real Rinit = 4400 from (0:inf);     // Fig.3a/b bias       [demo 500]

// charge-controlled update (dG linear in pulse amplitude, paper Fig. S4)
parameter real Q_ref    = 0.5p from (0:inf);  // C per unit pulse (= 50 pA x 10 ms)
parameter real n_states = 650  from (0:inf);  // small step ~1.6 uS -> -30 dip + fine LTP/LTD  [demo 17]
parameter real nu_p     = 0.02 from [0:inf);  // near-linear (paper R^2 = 0.994)
parameter real nu_d     = 0.02 from [0:inf);  // symmetric at small signal           [demo 0.58]
parameter real polarity = -1.0 from [-1:1];   // -1: positive (intercalation) I potentiates

// volatile (short-term) relaxation.  tau1 = w^2/2D = 22 ms, tau2 = l^2/2D =
// 315 ms (in-plane diffusion); tau3 = 19 s (LFP exchange).  c3 = 2 keeps the
// slow 19 s tail ON (Fig.3a recovers over ~40 s).
parameter real kappa_v = 0.68  from [0:1);    // retained frac: dR -30 -> dR' -10  [demo 0.705]
parameter real kappa_d = 0.68  from [0:1);    // = kappa_v at small signal         [demo 0.680]
parameter real w    = 4u     from (0:inf);    // device width
parameter real l    = 15u    from (0:inf);    // device length
parameter real D    = 360p   from (0:inf);    // m^2/s; 3.6e-10 -> tau1 22 ms, tau2 315 ms
parameter real tao3 = 19     from (0:inf);
parameter real c1 = 1   from [0:inf);         // pool weights -> 0.25 / 0.25 / 0.50  [demo 1/1/0]
parameter real c2 = 1   from [0:inf);
parameter real c3 = 2   from [0:inf);
parameter real tau_scale = 1.0 from (0:inf);

// long-term retention (negligible over seconds; paper: 3.2% over 13 h)
parameter real tau_retention = 1.31M from (0:inf);
parameter real R_eq          = 10k  from (0:inf);   // delithiated equilibrium  [demo 8333]

// spike-timing-dependent plasticity - EDGE-TRIGGERED 3-exponential impulse
// lock-in, an exact port of the discrete per-pulse rule in model_v2.py (the
// VERIFIED reference the GUI runs, paper Fig.4b fit R^2=1.0).  Each pulse ONSET
// is a @(cross) event on the gate current that instantaneously (mirroring
// EcfetV2.step()): (1) decays both 3-component eligibility traces by
// exp(-dt/tau_i) since the previous onset (tau1=22ms, tau2=315ms, tau3=19s =
// the SAME device taus as the volatile pools), (2) locks A_stdp * sum(OPPOSITE
// surviving trace) into the nonvolatile state and CONSUMES (zeroes) that trace,
// (3) clamps the nonvolatile state G_nv = V(n_nv) + lock to [Gmin, Gmax],
// (4) SATURATES its own trace components at the normalized one-pulse weights
// stdp_c1/2/3 (min(tr + w, w)).  The lock lives in the accumulator stdp_lock;
// it relaxes with tau_retention exactly like the twin's G_nv (the retention
// ODE is linear, so the lock part decays toward 0 while n_nv carries G_eq).
// Twin G_nv == V(n_nv) + V(n_stdp).  The +side window is therefore the paper 3-exp
//   dG(dt) = A_stdp*(scn1 e^-dt/tau1 + scn2 e^-dt/tau2 + scn3 e^-dt/tau3),
// peak ~A_stdp at |dt|->0, with the slow 19s tail (~0.7 uS out to 1800 ms); the
// -side is its anti-symmetric mirror.  Parameter names/defaults are checked
// against model_v2.py by vatester/tools_ext.check_consistency; waveform-level
// validation of this .va against a SPICE simulator is not yet done and is
// tracked in validation/ (being added).
// This REPLACES the old continuous trace, which under-charged for short pulses
// and gave a weak, mis-shaped Spectre window.  Same-polarity trains (Fig.3
// LTP/LTD, panel-c pulses) leave the opposite trace at ~0, so the lock-in stays
// inert there - Fig.3 is unaffected.  Set A_stdp = 0 to disable STDP.
// NOT mirrored (cannot be expressed faithfully in continuous time):
//  * Twin onset = |Ieff| goes from below to >= I_drift_th BETWEEN TWO SAMPLES;
//    a direct +I -> -I reversal with no sub-threshold sample gives no twin
//    onset, while I(IGsc) here is continuous and always crosses |I| <
//    I_drift_th, so @(cross) fires.  Pulses separated by a gap agree.
//  * Twin per-pulse cycle-to-cycle variability (sigma_c2c, seed; Python
//    random.gauss stream) has no equivalent here: this .va is sigma_c2c = 0.
parameter real A_stdp   = 4.5e-6 from [0:inf); // S, window peak at dt->0 (paper ~4.5 uS)
parameter real tau_stdp = 0.02 from (0:inf);   // s, legacy single-tau (unused by the 3-exp trace)
parameter real stdp_c1  = 0.39 from [0:inf);   // trace weight on tau1 (22 ms)
parameter real stdp_c2  = 0.44 from [0:inf);   // trace weight on tau2 (315 ms)
parameter real stdp_c3  = 0.17 from [0:inf);   // trace weight on tau3 (19 s) -> the slow tail

// gate threshold / leak (same semantics as v1)
parameter real I_drift_th       = 1p  from [0:inf);
parameter real leak_drift_scale = 0.0 from [0:1];

real Gmin, Gmax, G_eq, dG_unit;
real tau1, tau2, tau3v, csum, cn1, cn2, cn3;
real absI, Ieff, G_total, x, win, u, sgn, kap;
// edge-triggered 3-exponential STDP state (1 unit == 1, lock in S)
real tr_p1, tr_p2, tr_p3, tr_d1, tr_d2, tr_d3;
real stdp_lock, t_evt, dt_evt, gnv_now, stdp_eff;
real ssum, scn1, scn2, scn3;

analog begin
    Gmin    = 1.0 / Rmax;
    Gmax    = 1.0 / Rmin;
    G_eq    = 1.0 / R_eq;
    dG_unit = (Gmax - Gmin) / n_states;

    tau1  = (w*w) / (2.0*D) * tau_scale;
    tau2  = (l*l) / (2.0*D) * tau_scale;
    tau3v = tao3 * tau_scale;

    csum = c1 + c2 + c3;
    cn1 = c1 / csum;
    cn2 = c2 / csum;
    cn3 = c3 / csum;

    ssum = stdp_c1 + stdp_c2 + stdp_c3;   // normalized STDP trace weights
    scn1 = stdp_c1 / ssum;
    scn2 = stdp_c2 / ssum;
    scn3 = stdp_c3 / ssum;

    V(ignd) <+ 0;

    // ---- edge-triggered STDP state init ----
    @(initial_step) begin
        tr_p1 = 0.0; tr_p2 = 0.0; tr_p3 = 0.0;
        tr_d1 = 0.0; tr_d2 = 0.0; tr_d3 = 0.0;
        stdp_lock = 0.0; t_evt = 0.0;
    end

    // gate threshold / leak scaling
    absI = abs(I(IGsc));
    if (absI < I_drift_th)
        Ieff = leak_drift_scale * I(IGsc);
    else
        Ieff = I(IGsc);

    // ---- STDP 3-exp impulse lock-in: fires once at each pulse ONSET ----
    // Each trace component decays with its own device tau (tau1/tau2/tau3v);
    // the lock-in pairs a pulse with sum() of the surviving OPPOSITE trace.
    // A positive-current pulse begins (I(IGsc) crosses +I_drift_th upward):
    // Both blocks mirror EcfetV2.step() onset branch (twin model_v2.py).
    @(cross(I(IGsc) - I_drift_th, +1)) begin
        dt_evt = $abstime - t_evt;
        // twin step(): tr_pot/tr_dep *= exp(-dt/tau_i) every step
        tr_p1 = tr_p1*exp(-dt_evt/tau1); tr_p2 = tr_p2*exp(-dt_evt/tau2); tr_p3 = tr_p3*exp(-dt_evt/tau3v);
        tr_d1 = tr_d1*exp(-dt_evt/tau1); tr_d2 = tr_d2*exp(-dt_evt/tau2); tr_d3 = tr_d3*exp(-dt_evt/tau3v);
        // twin step() 2): G_nv retention, applied to the lock part (linear ODE)
        stdp_lock = stdp_lock*exp(-dt_evt/tau_retention);
        t_evt = $abstime;
        if (-polarity > 0.0) begin          // positive current potentiates
            stdp_lock = stdp_lock + A_stdp*(tr_d1 + tr_d2 + tr_d3);   // pairs with depression trace
            tr_d1 = 0.0; tr_d2 = 0.0; tr_d3 = 0.0;                    // twin: consume tr_dep
            tr_p1 = min(tr_p1 + scn1, scn1);                          // twin: saturate tr_pot
            tr_p2 = min(tr_p2 + scn2, scn2);                          //   at 1-pulse weight
            tr_p3 = min(tr_p3 + scn3, scn3);
        end else begin
            stdp_lock = stdp_lock - A_stdp*(tr_p1 + tr_p2 + tr_p3);
            tr_p1 = 0.0; tr_p2 = 0.0; tr_p3 = 0.0;                    // twin: consume tr_pot
            tr_d1 = min(tr_d1 + scn1, scn1);                          // twin: saturate tr_dep
            tr_d2 = min(tr_d2 + scn2, scn2);
            tr_d3 = min(tr_d3 + scn3, scn3);
        end
        // twin: G_nv = min(max(G_nv, Gmin), Gmax) at every onset (G_nv = n_nv + lock)
        gnv_now = V(n_nv,ignd) + stdp_lock;
        stdp_lock = min(max(gnv_now, Gmin), Gmax) - V(n_nv,ignd);
    end
    // A negative-current pulse begins (I(IGsc) crosses -I_drift_th downward):
    @(cross(I(IGsc) + I_drift_th, -1)) begin
        dt_evt = $abstime - t_evt;
        // twin step(): tr_pot/tr_dep *= exp(-dt/tau_i) every step
        tr_p1 = tr_p1*exp(-dt_evt/tau1); tr_p2 = tr_p2*exp(-dt_evt/tau2); tr_p3 = tr_p3*exp(-dt_evt/tau3v);
        tr_d1 = tr_d1*exp(-dt_evt/tau1); tr_d2 = tr_d2*exp(-dt_evt/tau2); tr_d3 = tr_d3*exp(-dt_evt/tau3v);
        // twin step() 2): G_nv retention, applied to the lock part (linear ODE)
        stdp_lock = stdp_lock*exp(-dt_evt/tau_retention);
        t_evt = $abstime;
        if (polarity > 0.0) begin           // negative current potentiates
            stdp_lock = stdp_lock + A_stdp*(tr_d1 + tr_d2 + tr_d3);
            tr_d1 = 0.0; tr_d2 = 0.0; tr_d3 = 0.0;                    // twin: consume tr_dep
            tr_p1 = min(tr_p1 + scn1, scn1);                          // twin: saturate tr_pot
            tr_p2 = min(tr_p2 + scn2, scn2);
            tr_p3 = min(tr_p3 + scn3, scn3);
        end else begin
            stdp_lock = stdp_lock - A_stdp*(tr_p1 + tr_p2 + tr_p3);   // pairs with potentiation trace
            tr_p1 = 0.0; tr_p2 = 0.0; tr_p3 = 0.0;                    // twin: consume tr_pot
            tr_d1 = min(tr_d1 + scn1, scn1);                          // twin: saturate tr_dep
            tr_d2 = min(tr_d2 + scn2, scn2);
            tr_d3 = min(tr_d3 + scn3, scn3);
        end
        // twin: G_nv = min(max(G_nv, Gmin), Gmax) at every onset (G_nv = n_nv + lock)
        gnv_now = V(n_nv,ignd) + stdp_lock;
        stdp_lock = min(max(gnv_now, Gmin), Gmax) - V(n_nv,ignd);
    end

    // locked-in STDP part of the twin's G_nv, relaxing with tau_retention
    // between onsets (twin step() 2), exact for the linear retention ODE)
    stdp_eff = stdp_lock * exp(-($abstime - t_evt) / tau_retention);

    // total conductance = nonvolatile + volatile pools + locked-in STDP
    G_total = V(n_nv,ignd) + V(n_v1,ignd) + V(n_v2,ignd) + V(n_v3,ignd)
              + stdp_eff;
    if (G_total < Gmin) G_total = Gmin;
    if (G_total > Gmax) G_total = Gmax;
    x = (G_total - Gmin) / (Gmax - Gmin);

    // charge-driven update rate u (S/s), soft-bounded
    if (Ieff != 0.0) begin
        if (Ieff > 0)
            sgn = -polarity;     // polarity=-1: positive I raises G (lowers R) -> potentiation
        else
            sgn = polarity;

        if (sgn > 0)
            win = limexp(-nu_p * x);            // conductance rising
        else
            win = limexp(-nu_d * (1.0 - x));    // conductance falling

        u = sgn * dG_unit * abs(Ieff) / Q_ref * win;

        // hard stop exactly at the range edges
        if ((G_total >= Gmax && u > 0) || (G_total <= Gmin && u < 0))
            u = 0.0;

        kap = (sgn > 0) ? kappa_v : kappa_d;   // direction-specific volatile frac
    end else begin
        u = 0.0;
        kap = kappa_v;
    end

    if (analysis("ic")) begin
        V(n_nv,ignd) <+ min(max(1.0 / Rinit, Gmin), Gmax);   // twin reset(): clamped
        V(n_v1,ignd) <+ 0.0;
        V(n_v2,ignd) <+ 0.0;
        V(n_v3,ignd) <+ 0.0;
    end else begin
        // d(G_nv)/dt = (1-kap)*u - (G_nv - G_eq)/tau_retention
        // kap = kappa_v for potentiation, kappa_d for depression.  The STDP
        // term is applied discretely via stdp_lock (above), not as a rate here.
        I(n_nv,ignd) <+ ddt(V(n_nv,ignd))
                        - (1.0 - kap) * u
                        + (V(n_nv,ignd) - G_eq) / tau_retention;

        // d(G_vi)/dt = kap*cni*u - G_vi/taui
        I(n_v1,ignd) <+ ddt(V(n_v1,ignd)) - kap*cn1*u + V(n_v1,ignd)/tau1;
        I(n_v2,ignd) <+ ddt(V(n_v2,ignd)) - kap*cn2*u + V(n_v2,ignd)/tau2;
        I(n_v3,ignd) <+ ddt(V(n_v3,ignd)) - kap*cn3*u + V(n_v3,ignd)/tau3v;
    end

    // outputs
    V(Rmem) <+ 1.0 / G_total;
    V(mem)  <+ I(mem) / G_total;
    // isolated STDP window readout (S, 1 V == 1 S): plot V(I54.n_stdp) vs dT to
    // compare directly to the GUI window - free of volatile/direct-write background
    V(n_stdp) <+ stdp_eff;   // twin G_nv == V(n_nv) + V(n_stdp)
end

endmodule
