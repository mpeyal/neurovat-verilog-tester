`include "constants.vams"
`include "disciplines.vams"
`timescale 1us / 1us

module basic_v1_Diffu_Drft_verilog(In,Out,IGsc,Rmem);
output Rmem; inout In, Out;
input IGsc;

electrical In, Out, IGsc, capgnd, capactive, Rmem;

branch (In,Out) mem;
branch (capactive,capgnd) cap;

parameter real Rmin   = 0.1k;
parameter real Rmax   = 10k;
parameter real Rinit  = 500;
parameter real Rdrift1c = 20e12;

parameter real w = 2.828u;
parameter real l = 4u;
parameter real D = 0.4n;

parameter real tao3 = 19;
parameter real c1  = 10;
parameter real c2  = 9.9;
parameter real c3  = 0.1;

parameter real tau_scale = 1.0 from (0:inf);

parameter real I_drift_th = 1p from [0:inf);
parameter real leak_drift_scale = 0.0 from [0:1];

parameter real G_sat = 1e6 from (0:inf);

real tao2, tao1;
real tao1_eff, tao2_eff, tao3_eff;

real M;
real source_dir, t, sc_pulse_arrived;
real diffusion_start_time, diffu_M, M_before_diffusion;
real absI, Ieff, Idrive;
real Vcap_min, Vcap_max, M_cap;

integer drift_on;
integer prev_drift_on;
integer pulse_started_now;
integer pulse_ended_now;

analog begin
    tao2 = (l*l)/(2*D);
    tao1 = (w*w)/(2*D);

    tao1_eff = tao1 * tau_scale;
    tao2_eff = tao2 * tau_scale;
    tao3_eff = tao3 * tau_scale;

    Vcap_min = Rmin / Rdrift1c;
    Vcap_max = Rmax / Rdrift1c;

    if (analysis("ic")) begin
        M = Rinit;
        if (M < Rmin) M = Rmin;
        if (M > Rmax) M = Rmax;

        V(cap) <+ M / Rdrift1c;
        V(capgnd) <+ 0;

        sc_pulse_arrived = 0;
        source_dir = 1;
        t = 0;
        diffusion_start_time = 0;
        M_before_diffusion = M;

        drift_on = 0;
        prev_drift_on = 0;
        pulse_started_now = 0;
        pulse_ended_now = 0;
    end else begin

        absI = abs(I(IGsc));
        if (absI < I_drift_th)
            Ieff = leak_drift_scale * I(IGsc);
        else
            Ieff = I(IGsc);

        if (abs(Ieff) >= I_drift_th)
            drift_on = 1;
        else
            drift_on = 0;

        pulse_started_now = (drift_on == 1) && (prev_drift_on == 0);
        pulse_ended_now   = (drift_on == 0) && (prev_drift_on == 1);

        M_cap = V(cap) * Rdrift1c;
        Idrive = Ieff;

        if ((M_cap >= Rmax && Ieff > 0) || (M_cap <= Rmin && Ieff < 0))
            Idrive = 0.0;

        I(cap) <+ Idrive;
        V(capgnd) <+ 0;
        I(cap) <+ ddt(V(cap));

        if (V(cap) > Vcap_max)
            I(cap) <+ G_sat * (V(cap) - Vcap_max);
        else if (V(cap) < Vcap_min)
            I(cap) <+ G_sat * (V(cap) - Vcap_min);

        // pulse start: align internal integrator state with present M
        if (pulse_started_now) begin
            V(cap) <+ M / Rdrift1c;

            if (Ieff > 0)
                source_dir = 1;
            else
                source_dir = -1;
        end

        // drift phase
        if (drift_on) begin
            M = V(cap) * Rdrift1c;

            if (M < Rmin) M = Rmin;
            if (M > Rmax) M = Rmax;

            if (Ieff > 0)
                source_dir = 1;
            else
                source_dir = -1;
        end

        // pulse end: snapshot final drifted state
        if (pulse_ended_now) begin
            M_before_diffusion = M;
            diffusion_start_time = $abstime;
            sc_pulse_arrived = 1;
        end

        // diffusion phase
        if ((drift_on == 0) && (sc_pulse_arrived == 1) &&
            (($abstime - diffusion_start_time) < 1)) begin

            t = $abstime - diffusion_start_time;

            diffu_M = (c1 * exp(-t/tao1_eff)) +
                      (c2 * exp(-t/tao2_eff)) +
                      (c3 * exp(-t/tao3_eff));

            if (diffu_M < 0)
                diffu_M = 0;

            if (source_dir < 0)
                M = M_before_diffusion + diffu_M;
            else
                M = M_before_diffusion - diffu_M;

            if (M < Rmin) M = Rmin;
            if (M > Rmax) M = Rmax;

            V(cap) <+ M / Rdrift1c;
        end else begin
            t = 0;

            if ((drift_on == 0) && (($abstime - diffusion_start_time) >= 1))
                sc_pulse_arrived = 0;
        end

        prev_drift_on = drift_on;
    end

    V(Rmem) <+ M;
    V(mem)  <+ I(mem) * M;
end

endmodule
