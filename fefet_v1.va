// FeFET synaptic device - Verilog-A twin of ecfet/model_fefet.py
//
// Normalized remnant polarization P lives on internal node "pol"
// (1 V === P = 1).  Merz-law field-activated switching toward sign(Vg),
// depolarization toward 0 with tau_ret, logistic conductance readout
// between drain and source.  No switch branches, smooth limexp -> clean
// convergence in Spectre.
//
// Sign convention: positive gate voltage potentiates (G up).

`include "constants.vams"
`include "disciplines.vams"

module fefet_v1(g, d, s);
    inout g, d, s;
    electrical g, d, s;
    electrical pol;                  // internal state node: V(pol) = P in [-1, 1]

    // resistance bounds
    parameter real Rmin     = 0.1e3  from (0:inf);
    parameter real Rmax     = 10e3   from (0:inf);
    parameter real P_init   = 0.0    from [-1:1];

    // ferroelectric switching (Merz law)
    parameter real Vc       = 0.6    from (0:inf);   // coercive voltage (V)
    parameter real V0       = 0.15   from (0:inf);   // activation steepness (V)
    parameter real tau0     = 5e-3   from (0:inf);   // switching tau at |V|=Vc (s)

    // retention / depolarization
    parameter real tau_ret  = 1e4    from (0:inf);

    // electrostatics -> readout
    parameter real dVth_max = 0.8;
    parameter real Vth0     = 0.0;
    parameter real Vread    = 0.0;
    parameter real SS       = 0.25   from (0:inf);

    parameter real V_th_min = 1e-3   from [0:inf);   // gate dead-zone (V)

    real Gmin, Gmax, Vg, rate, target, P, Vth, x, Gch;

    analog begin
        @(initial_step) begin
            Gmin = 1.0 / Rmax;
            Gmax = 1.0 / Rmin;
        end

        Vg = V(g, s);
        P  = V(pol);

        // dP/dt = rate*(target - P) - P/tau_ret   (rate ~ 0 below Vc)
        if (abs(Vg) >= V_th_min) begin
            rate   = limexp((abs(Vg) - Vc) / V0) / tau0;
            target = (Vg > 0) ? 1.0 : -1.0;
        end else begin
            rate   = 0.0;
            target = 0.0;
        end

        I(pol) <+ ddt(V(pol));
        I(pol) <+ -rate * (target - V(pol));
        I(pol) <+ V(pol) / tau_ret;

        // logistic readout: Vth(P) -> channel conductance
        Vth = Vth0 - 0.5 * dVth_max * P;
        x   = 1.0 / (1.0 + limexp(-(Vread - Vth) / SS));
        Gch = Gmin + (Gmax - Gmin) * x;

        I(d, s) <+ Gch * V(d, s);
    end
endmodule
